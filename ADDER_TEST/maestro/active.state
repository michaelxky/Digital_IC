ADE simulation setup
Test project_ADDER_TEST_1: project/ADDER_TEST/schematic, simulator spectre
  Models: /home/dicd26/dicd25039/hspice_nom.include
  Temperature: 90
  Analysis tran: stop=90n errpreset=conservative
  Output MeanSRise = ((riseTime(v("/S<0>" ?result "tran") 0 nil 1 nil 10 90) + riseTime(v("/S<1>" ?result "tran") 0 nil 1 nil 10 90) + riseTime(v("/S<2>" ?result "tran") 0 nil 1 nil 10 90) + riseTime(v("/S<3>" ?result "tran") 0 nil 1 nil 10 90) + riseTime(v("/S<4>" ?result "tran") 0 nil 1 nil 10 90) + riseTime(v("/S<5>" ?result "tran") 0 nil 1 nil 10 90) + riseTime(v("/S<6>" ?result "tran") 0 nil 1 nil 10 90) + riseTime(v("/S<7>" ?result "tran") 0 nil 1 nil 10 90) + riseTime(v("/S<8>" ?result "tran") 0 nil 1 nil 10 90) + riseTime(v("/S<9>" ?result "tran") 0 nil 1 nil 10 90) + riseTime(v("/S<10>" ?result "tran") 0 nil 1 nil 10 90) + riseTime(v("/S<11>" ?result "tran") 0 nil 1 nil 10 90) + riseTime(v("/S<12>" ?result "tran") 0 nil 1 nil 10 90) + riseTime(v("/S<13>" ?result "tran") 0 nil 1 nil 10 90) + riseTime(v("/S<14>" ?result "tran") 0 nil 1 nil 10 90) + riseTime(v("/S<15>" ?result "tran") 0 nil 1 nil 10 90)) / 16)
  Output MaxRsieS = max(riseTime(v("/S<0>" ?result "tran") 0 nil 1 nil 10 90) riseTime(v("/S<1>" ?result "tran") 0 nil 1 nil 10 90) riseTime(v("/S<2>" ?result "tran") 0 nil 1 nil 10 90) riseTime(v("/S<3>" ?result "tran") 0 nil 1 nil 10 90) riseTime(v("/S<4>" ?result "tran") 0 nil 1 nil 10 90) riseTime(v("/S<5>" ?result "tran") 0 nil 1 nil 10 90) riseTime(v("/S<6>" ?result "tran") 0 nil 1 nil 10 90) riseTime(v("/S<7>" ?result "tran") 0 nil 1 nil 10 90) riseTime(v("/S<8>" ?result "tran") 0 nil 1 nil 10 90) riseTime(v("/S<9>" ?result "tran") 0 nil 1 nil 10 90) riseTime(v("/S<10>" ?result "tran") 0 nil 1 nil 10 90) riseTime(v("/S<11>" ?result "tran") 0 nil 1 nil 10 90) riseTime(v("/S<12>" ?result "tran") 0 nil 1 nil 10 90) riseTime(v("/S<13>" ?result "tran") 0 nil 1 nil 10 90) riseTime(v("/S<14>" ?result "tran") 0 nil 1 nil 10 90) riseTime(v("/S<15>" ?result "tran") 0 nil 1 nil 10 90))
  Output MaxFallS = max(fallTime(v("/S<0>" ?result "tran") 1 nil 0 nil 10 90) fallTime(v("/S<1>" ?result "tran") 1 nil 0 nil 10 90) fallTime(v("/S<2>" ?result "tran") 1 nil 0 nil 10 90) fallTime(v("/S<3>" ?result "tran") 1 nil 0 nil 10 90) fallTime(v("/S<4>" ?result "tran") 1 nil 0 nil 10 90) fallTime(v("/S<5>" ?result "tran") 1 nil 0 nil 10 90) fallTime(v("/S<6>" ?result "tran") 1 nil 0 nil 10 90) fallTime(v("/S<7>" ?result "tran") 1 nil 0 nil 10 90) fallTime(v("/S<8>" ?result "tran") 1 nil 0 nil 10 90) fallTime(v("/S<9>" ?result "tran") 1 nil 0 nil 10 90) fallTime(v("/S<10>" ?result "tran") 1 nil 0 nil 10 90) fallTime(v("/S<11>" ?result "tran") 1 nil 0 nil 10 90) fallTime(v("/S<12>" ?result "tran") 1 nil 0 nil 10 90) fallTime(v("/S<13>" ?result "tran") 1 nil 0 nil 10 90) fallTime(v("/S<14>" ?result "tran") 1 nil 0 nil 10 90) fallTime(v("/S<15>" ?result "tran") 1 nil 0 nil 10 90))
  Output MeanSFall = ((fallTime(v("/S<0>" ?result "tran") 1 nil 0 nil 10 90) + fallTime(v("/S<1>" ?result "tran") 1 nil 0 nil 10 90) + fallTime(v("/S<2>" ?result "tran") 1 nil 0 nil 10 90) + fallTime(v("/S<3>" ?result "tran") 1 nil 0 nil 10 90) + fallTime(v("/S<4>" ?result "tran") 1 nil 0 nil 10 90) + fallTime(v("/S<5>" ?result "tran") 1 nil 0 nil 10 90) + fallTime(v("/S<6>" ?result "tran") 1 nil 0 nil 10 90) + fallTime(v("/S<7>" ?result "tran") 1 nil 0 nil 10 90) + fallTime(v("/S<8>" ?result "tran") 1 nil 0 nil 10 90) + fallTime(v("/S<9>" ?result "tran") 1 nil 0 nil 10 90) + fallTime(v("/S<10>" ?result "tran") 1 nil 0 nil 10 90) + fallTime(v("/S<11>" ?result "tran") 1 nil 0 nil 10 90) + fallTime(v("/S<12>" ?result "tran") 1 nil 0 nil 10 90) + fallTime(v("/S<13>" ?result "tran") 1 nil 0 nil 10 90) + fallTime(v("/S<14>" ?result "tran") 1 nil 0 nil 10 90) + fallTime(v("/S<15>" ?result "tran") 1 nil 0 nil 10 90)) / 16.0)
  Output RiseC = riseTime(v("/Cout" ?result "tran") 0 nil 1 nil 10 90)
  Output FallC = fallTime(v("/Cout" ?result "tran") 1 nil 0 nil 10 90)
  Output FallS = fallTime(v("/S<15:0>" ?result "tran") 1 nil 0 nil 10 90)
  Output RiseS = riseTime(v("/S<15:0>" ?result "tran") 0 nil 1 nil 10 90)
  Output LogicCheck = (((1 * round((value(v("/S<0>" ?result "tran") 6e-09) + 0.1))) + (2 * round((value(v("/S<1>" ?result "tran") 6e-09) + 0.1))) + (4 * round((value(v("/S<2>" ?result "tran") 6e-09) + 0.1))) + (8 * round((value(v("/S<3>" ?result "tran") 6e-09) + 0.1))) + (16 * round((value(v("/S<4>" ?result "tran") 6e-09) + 0.1))) + (32 * round((value(v("/S<5>" ?result "tran") 6e-09) + 0.1))) + (64 * round((value(v("/S<6>" ?result "tran") 6e-09) + 0.1))) + (128 * round((value(v("/S<7>" ?result "tran") 6e-09) + 0.1))) + (256 * round((value(v("/S<8>" ?result "tran") 6e-09) + 0.1))) + (512 * round((value(v("/S<9>" ?result "tran") 6e-09) + 0.1))) + (1024 * round((value(v("/S<10>" ?result "tran") 6e-09) + 0.1))) + (2048 * round((value(v("/S<11>" ?result "tran") 6e-09) + 0.1))) + (4096 * round((value(v("/S<12>" ?result "tran") 6e-09) + 0.1))) + (8192 * round((value(v("/S<13>" ?result "tran") 6e-09) + 0.1))) + (16384 * round((value(v("/S<14>" ?result "tran") 6e-09) + 0.1))) + (32768 * round((value(v("/S<15>" ?result "tran") 6e-09) + 0.1))) + (65536 * round((value(v("/Cout" ?result "tran") 6e-09) + 0.1)))) - ((1 * round((value(v("/A<0>" ?result "tran") 6e-09) + 0.1))) + (2 * round((value(v("/A<1>" ?result "tran") 6e-09) + 0.1))) + (4 * round((value(v("/A<2>" ?result "tran") 6e-09) + 0.1))) + (8 * round((value(v("/A<3>" ?result "tran") 6e-09) + 0.1))) + (16 * round((value(v("/A<4>" ?result "tran") 6e-09) + 0.1))) + (32 * round((value(v("/A<5>" ?result "tran") 6e-09) + 0.1))) + (64 * round((value(v("/A<6>" ?result "tran") 6e-09) + 0.1))) + (128 * round((value(v("/A<7>" ?result "tran") 6e-09) + 0.1))) + (256 * round((value(v("/A<8>" ?result "tran") 6e-09) + 0.1))) + (512 * round((value(v("/A<9>" ?result "tran") 6e-09) + 0.1))) + (1024 * round((value(v("/A<10>" ?result "tran") 6e-09) + 0.1))) + (2048 * round((value(v("/A<11>" ?result "tran") 6e-09) + 0.1))) + (4096 * round((value(v("/A<12>" ?result "tran") 6e-09) + 0.1))) + (8192 * round((value(v("/A<13>" ?result "tran") 6e-09) + 0.1))) + (16384 * round((value(v("/A<14>" ?result "tran") 6e-09) + 0.1))) + (32768 * round((value(v("/A<15>" ?result "tran") 6e-09) + 0.1))) + ((1 * round((value(v("/B<0>" ?result "tran") 6e-09) + 0.1))) + (2 * round((value(v("/B<1>" ?result "tran") 6e-09) + 0.1))) + (4 * round((value(v("/B<2>" ?result "tran") 6e-09) + 0.1))) + (8 * round((value(v("/B<3>" ?result "tran") 6e-09) + 0.1))) + (16 * round((value(v("/B<4>" ?result "tran") 6e-09) + 0.1))) + (32 * round((value(v("/B<5>" ?result "tran") 6e-09) + 0.1))) + (64 * round((value(v("/B<6>" ?result "tran") 6e-09) + 0.1))) + (128 * round((value(v("/B<7>" ?result "tran") 6e-09) + 0.1))) + (256 * round((value(v("/B<8>" ?result "tran") 6e-09) + 0.1))) + (512 * round((value(v("/B<9>" ?result "tran") 6e-09) + 0.1))) + (1024 * round((value(v("/B<10>" ?result "tran") 6e-09) + 0.1))) + (2048 * round((value(v("/B<11>" ?result "tran") 6e-09) + 0.1))) + (4096 * round((value(v("/B<12>" ?result "tran") 6e-09) + 0.1))) + (8192 * round((value(v("/B<13>" ?result "tran") 6e-09) + 0.1))) + (16384 * round((value(v("/B<14>" ?result "tran") 6e-09) + 0.1))) + (32768 * round((value(v("/B<15>" ?result "tran") 6e-09) + 0.1)))) + round((value(v("/Cin" ?result "tran") 6e-09) + 0.1))))
  Signals: /A<15:0>, /B<15:0>, /S<15:0>, /Cout, /Cin
Run mode: Single Run, Sweeps and Corners
