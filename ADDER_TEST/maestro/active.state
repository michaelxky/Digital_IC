ADE simulation setup
Test project_ADDER_TEST_1: project/ADDER_TEST/schematic, simulator spectre
  Models: /home/dicd26/dicd25088/hspice_nom.include
  Temperature: 90
  Analysis tran: stop=90n errpreset=conservative
  Signals: /S<8>, /S<9>, /I0/G8_0, /I0/P9_9, /I0/G9_0, /I0/P10_10
Run mode: Single Run, Sweeps and Corners
