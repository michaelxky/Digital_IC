ADE simulation setup
Test project_ADDER_TEST_1: project/ADDER_TEST/schematic, simulator spectre
  Models: /home/dicd26/dicd25088/hspice_nom.include
  Temperature: 90
  Analysis tran: stop=90n errpreset=conservative
  Output MeanSRise = ((riseTime(v("/S<0>" ?result "tran") 0 nil 1 nil 10 90) + riseTime(v("/S<1>" ?result "tran") 0 nil 1 nil 10 90) + riseTime(v("/S<2>" ?result "tran") 0 nil 1 nil 10 90) + riseTime(v("/S<3>" ?result "tran") 0 nil 1 nil 10 90) + riseTime(v("/S<4>" ?result "tran") 0 nil 1 nil 10 90) + riseTime(v("/S<5>" ?result "tran") 0 nil 1 nil 10 90) + riseTime(v("/S<6>" ?result "tran") 0 nil 1 nil 10 90) + riseTime(v("/S<7>" ?result "tran") 0 nil 1 nil 10 90) + riseTime(v("/S<8>" ?result "tran") 0 nil 1 nil 10 90) + riseTime(v("/S<9>" ?result "tran") 0 nil 1 nil 10 90) + riseTime(v("/S<10>" ?result "tran") 0 nil 1 nil 10 90) + riseTime(v("/S<11>" ?result "tran") 0 nil 1 nil 10 90) + riseTime(v("/S<12>" ?result "tran") 0 nil 1 nil 10 90) + riseTime(v("/S<13>" ?result "tran") 0 nil 1 nil 10 90) + riseTime(v("/S<14>" ?result "tran") 0 nil 1 nil 10 90) + riseTime(v("/S<15>" ?result "tran") 0 nil 1 nil 10 90)) / 16)
  Output MaxRsieS = max(riseTime(v("/S<0>" ?result "tran") 0 nil 1 nil 10 90) riseTime(v("/S<1>" ?result "tran") 0 nil 1 nil 10 90) riseTime(v("/S<2>" ?result "tran") 0 nil 1 nil 10 90) riseTime(v("/S<3>" ?result "tran") 0 nil 1 nil 10 90) riseTime(v("/S<4>" ?result "tran") 0 nil 1 nil 10 90) riseTime(v("/S<5>" ?result "tran") 0 nil 1 nil 10 90) riseTime(v("/S<6>" ?result "tran") 0 nil 1 nil 10 90) riseTime(v("/S<7>" ?result "tran") 0 nil 1 nil 10 90) riseTime(v("/S<8>" ?result "tran") 0 nil 1 nil 10 90) riseTime(v("/S<9>" ?result "tran") 0 nil 1 nil 10 90) riseTime(v("/S<10>" ?result "tran") 0 nil 1 nil 10 90) riseTime(v("/S<11>" ?result "tran") 0 nil 1 nil 10 90) riseTime(v("/S<12>" ?result "tran") 0 nil 1 nil 10 90) riseTime(v("/S<13>" ?result "tran") 0 nil 1 nil 10 90) riseTime(v("/S<14>" ?result "tran") 0 nil 1 nil 10 90) riseTime(v("/S<15>" ?result "tran") 0 nil 1 nil 10 90))
  Output MaxFallS = max(fallTime(v("/S<0>" ?result "tran") 1 nil 0 nil 10 90) fallTime(v("/S<1>" ?result "tran") 1 nil 0 nil 10 90) fallTime(v("/S<2>" ?result "tran") 1 nil 0 nil 10 90) fallTime(v("/S<3>" ?result "tran") 1 nil 0 nil 10 90) fallTime(v("/S<4>" ?result "tran") 1 nil 0 nil 10 90) fallTime(v("/S<5>" ?result "tran") 1 nil 0 nil 10 90) fallTime(v("/S<6>" ?result "tran") 1 nil 0 nil 10 90) fallTime(v("/S<7>" ?result "tran") 1 nil 0 nil 10 90) fallTime(v("/S<8>" ?result "tran") 1 nil 0 nil 10 90) fallTime(v("/S<9>" ?result "tran") 1 nil 0 nil 10 90) fallTime(v("/S<10>" ?result "tran") 1 nil 0 nil 10 90) fallTime(v("/S<11>" ?result "tran") 1 nil 0 nil 10 90) fallTime(v("/S<12>" ?result "tran") 1 nil 0 nil 10 90) fallTime(v("/S<13>" ?result "tran") 1 nil 0 nil 10 90) fallTime(v("/S<14>" ?result "tran") 1 nil 0 nil 10 90) fallTime(v("/S<15>" ?result "tran") 1 nil 0 nil 10 90))
  Output MeanSFall = ((fallTime(v("/S<0>" ?result "tran") 1 nil 0 nil 10 90) + fallTime(v("/S<1>" ?result "tran") 1 nil 0 nil 10 90) + fallTime(v("/S<2>" ?result "tran") 1 nil 0 nil 10 90) + fallTime(v("/S<3>" ?result "tran") 1 nil 0 nil 10 90) + fallTime(v("/S<4>" ?result "tran") 1 nil 0 nil 10 90) + fallTime(v("/S<5>" ?result "tran") 1 nil 0 nil 10 90) + fallTime(v("/S<6>" ?result "tran") 1 nil 0 nil 10 90) + fallTime(v("/S<7>" ?result "tran") 1 nil 0 nil 10 90) + fallTime(v("/S<8>" ?result "tran") 1 nil 0 nil 10 90) + fallTime(v("/S<9>" ?result "tran") 1 nil 0 nil 10 90) + fallTime(v("/S<10>" ?result "tran") 1 nil 0 nil 10 90) + fallTime(v("/S<11>" ?result "tran") 1 nil 0 nil 10 90) + fallTime(v("/S<12>" ?result "tran") 1 nil 0 nil 10 90) + fallTime(v("/S<13>" ?result "tran") 1 nil 0 nil 10 90) + fallTime(v("/S<14>" ?result "tran") 1 nil 0 nil 10 90) + fallTime(v("/S<15>" ?result "tran") 1 nil 0 nil 10 90)) / 16.0)
  Output RiseC = riseTime(v("/Cout" ?result "tran") 0 nil 1 nil 10 90)
  Output FallC = fallTime(v("/Cout" ?result "tran") 1 nil 0 nil 10 90)
  Output FallS = fallTime(v("/S<15:0>" ?result "tran") 1 nil 0 nil 10 90) (unticked)
  Output RiseS = riseTime(v("/S<15:0>" ?result "tran") 0 nil 1 nil 10 90) (unticked)
  Output LogicCheck = (((1 * round((value(v("/S<0>" ?result "tran") 6e-09) + 0.1))) + (2 * round((value(v("/S<1>" ?result "tran") 6e-09) + 0.1))) + (4 * round((value(v("/S<2>" ?result "tran") 6e-09) + 0.1))) + (8 * round((value(v("/S<3>" ?result "tran") 6e-09) + 0.1))) + (16 * round((value(v("/S<4>" ?result "tran") 6e-09) + 0.1))) + (32 * round((value(v("/S<5>" ?result "tran") 6e-09) + 0.1))) + (64 * round((value(v("/S<6>" ?result "tran") 6e-09) + 0.1))) + (128 * round((value(v("/S<7>" ?result "tran") 6e-09) + 0.1))) + (256 * round((value(v("/S<8>" ?result "tran") 6e-09) + 0.1))) + (512 * round((value(v("/S<9>" ?result "tran") 6e-09) + 0.1))) + (1024 * round((value(v("/S<10>" ?result "tran") 6e-09) + 0.1))) + (2048 * round((value(v("/S<11>" ?result "tran") 6e-09) + 0.1))) + (4096 * round((value(v("/S<12>" ?result "tran") 6e-09) + 0.1))) + (8192 * round((value(v("/S<13>" ?result "tran") 6e-09) + 0.1))) + (16384 * round((value(v("/S<14>" ?result "tran") 6e-09) + 0.1))) + (32768 * round((value(v("/S<15>" ?result "tran") 6e-09) + 0.1))) + (65536 * round((value(v("/Cout" ?result "tran") 6e-09) + 0.1)))) - ((1 * round((value(v("/A<0>" ?result "tran") 6e-09) + 0.1))) + (2 * round((value(v("/A<1>" ?result "tran") 6e-09) + 0.1))) + (4 * round((value(v("/A<2>" ?result "tran") 6e-09) + 0.1))) + (8 * round((value(v("/A<3>" ?result "tran") 6e-09) + 0.1))) + (16 * round((value(v("/A<4>" ?result "tran") 6e-09) + 0.1))) + (32 * round((value(v("/A<5>" ?result "tran") 6e-09) + 0.1))) + (64 * round((value(v("/A<6>" ?result "tran") 6e-09) + 0.1))) + (128 * round((value(v("/A<7>" ?result "tran") 6e-09) + 0.1))) + (256 * round((value(v("/A<8>" ?result "tran") 6e-09) + 0.1))) + (512 * round((value(v("/A<9>" ?result "tran") 6e-09) + 0.1))) + (1024 * round((value(v("/A<10>" ?result "tran") 6e-09) + 0.1))) + (2048 * round((value(v("/A<11>" ?result "tran") 6e-09) + 0.1))) + (4096 * round((value(v("/A<12>" ?result "tran") 6e-09) + 0.1))) + (8192 * round((value(v("/A<13>" ?result "tran") 6e-09) + 0.1))) + (16384 * round((value(v("/A<14>" ?result "tran") 6e-09) + 0.1))) + (32768 * round((value(v("/A<15>" ?result "tran") 6e-09) + 0.1))) + ((1 * round((value(v("/B<0>" ?result "tran") 6e-09) + 0.1))) + (2 * round((value(v("/B<1>" ?result "tran") 6e-09) + 0.1))) + (4 * round((value(v("/B<2>" ?result "tran") 6e-09) + 0.1))) + (8 * round((value(v("/B<3>" ?result "tran") 6e-09) + 0.1))) + (16 * round((value(v("/B<4>" ?result "tran") 6e-09) + 0.1))) + (32 * round((value(v("/B<5>" ?result "tran") 6e-09) + 0.1))) + (64 * round((value(v("/B<6>" ?result "tran") 6e-09) + 0.1))) + (128 * round((value(v("/B<7>" ?result "tran") 6e-09) + 0.1))) + (256 * round((value(v("/B<8>" ?result "tran") 6e-09) + 0.1))) + (512 * round((value(v("/B<9>" ?result "tran") 6e-09) + 0.1))) + (1024 * round((value(v("/B<10>" ?result "tran") 6e-09) + 0.1))) + (2048 * round((value(v("/B<11>" ?result "tran") 6e-09) + 0.1))) + (4096 * round((value(v("/B<12>" ?result "tran") 6e-09) + 0.1))) + (8192 * round((value(v("/B<13>" ?result "tran") 6e-09) + 0.1))) + (16384 * round((value(v("/B<14>" ?result "tran") 6e-09) + 0.1))) + (32768 * round((value(v("/B<15>" ?result "tran") 6e-09) + 0.1)))) + round((value(v("/Cin" ?result "tran") 6e-09) + 0.1)))) (unticked)
  Output delay(?wf1 v("/A<0>" ?result "tran") ?value1 0.5 ?edge1 "either" ?nth1 1 ?td1 0 ?tol1 nil ?wf2 v("/S<0>" ?result "tran") ?value2 0.5 ?edge2 "either" ?nth2 1 ?tol2 nil ?td2 nil ?stop nil ?multiple nil) (unticked)
  Output F0 = riseTime(v("/Cout" ?result "tran") 0 nil 1 nil 10 90 nil "time")
  Output F1 = fallTime(v("/Cout" ?result "tran") 1 nil 0 nil 10 90 nil "time")
  Output F2 = riseTime(v("/S<0>" ?result "tran") 0 nil 1 nil 10 90 nil "time")
  Output F3 = fallTime(v("/S<0>" ?result "tran") 1 nil 0 nil 10 90 nil "time")
  Output F4 = riseTime(v("/S<1>" ?result "tran") 0 nil 1 nil 10 90 nil "time")
  Output F5 = fallTime(v("/S<1>" ?result "tran") 1 nil 0 nil 10 90 nil "time")
  Output F6 = riseTime(v("/S<2>" ?result "tran") 0 nil 1 nil 10 90 nil "time")
  Output F7 = fallTime(v("/S<2>" ?result "tran") 1 nil 0 nil 10 90 nil "time")
  Output F8 = riseTime(v("/S<3>" ?result "tran") 0 nil 1 nil 10 90 nil "time")
  Output F9 = fallTime(v("/S<3>" ?result "tran") 1 nil 0 nil 10 90 nil "time")
  Output F10 = riseTime(v("/S<4>" ?result "tran") 0 nil 1 nil 10 90 nil "time")
  Output F11 = fallTime(v("/S<4>" ?result "tran") 1 nil 0 nil 10 90 nil "time")
  Output F12 = riseTime(v("/S<5>" ?result "tran") 0 nil 1 nil 10 90 nil "time")
  Output F13 = fallTime(v("/S<5>" ?result "tran") 1 nil 0 nil 10 90 nil "time")
  Output F14 = riseTime(v("/S<6>" ?result "tran") 0 nil 1 nil 10 90 nil "time")
  Output F15 = fallTime(v("/S<6>" ?result "tran") 1 nil 0 nil 10 90 nil "time")
  Output F16 = riseTime(v("/S<7>" ?result "tran") 0 nil 1 nil 10 90 nil "time")
  Output F17 = fallTime(v("/S<7>" ?result "tran") 1 nil 0 nil 10 90 nil "time")
  Output F18 = riseTime(v("/S<8>" ?result "tran") 0 nil 1 nil 10 90 nil "time")
  Output F19 = fallTime(v("/S<8>" ?result "tran") 1 nil 0 nil 10 90 nil "time")
  Output F20 = riseTime(v("/S<9>" ?result "tran") 0 nil 1 nil 10 90 nil "time")
  Output F21 = fallTime(v("/S<9>" ?result "tran") 1 nil 0 nil 10 90 nil "time")
  Output F22 = riseTime(v("/S<10>" ?result "tran") 0 nil 1 nil 10 90 nil "time")
  Output F23 = fallTime(v("/S<10>" ?result "tran") 1 nil 0 nil 10 90 nil "time")
  Output F24 = riseTime(v("/S<11>" ?result "tran") 0 nil 1 nil 10 90 nil "time")
  Output F25 = fallTime(v("/S<11>" ?result "tran") 1 nil 0 nil 10 90 nil "time")
  Output F26 = riseTime(v("/S<12>" ?result "tran") 0 nil 1 nil 10 90 nil "time")
  Output F27 = fallTime(v("/S<12>" ?result "tran") 1 nil 0 nil 10 90 nil "time")
  Output F28 = riseTime(v("/S<13>" ?result "tran") 0 nil 1 nil 10 90 nil "time")
  Output F29 = fallTime(v("/S<13>" ?result "tran") 1 nil 0 nil 10 90 nil "time")
  Output F30 = riseTime(v("/S<14>" ?result "tran") 0 nil 1 nil 10 90 nil "time")
  Output F31 = fallTime(v("/S<14>" ?result "tran") 1 nil 0 nil 10 90 nil "time")
  Output F32 = riseTime(v("/S<15>" ?result "tran") 0 nil 1 nil 10 90 nil "time")
  Output F33 = fallTime(v("/S<15>" ?result "tran") 1 nil 0 nil 10 90 nil "time")
  Output E7 = (((1 * round((value(v("/S<0>" ?result "tran") 6e-09) + 0.1))) + (2 * round((value(v("/S<1>" ?result "tran") 6e-09) + 0.1))) + (4 * round((value(v("/S<2>" ?result "tran") 6e-09) + 0.1))) + (8 * round((value(v("/S<3>" ?result "tran") 6e-09) + 0.1))) + (16 * round((value(v("/S<4>" ?result "tran") 6e-09) + 0.1))) + (32 * round((value(v("/S<5>" ?result "tran") 6e-09) + 0.1))) + (64 * round((value(v("/S<6>" ?result "tran") 6e-09) + 0.1))) + (128 * round((value(v("/S<7>" ?result "tran") 6e-09) + 0.1))) + (256 * round((value(v("/S<8>" ?result "tran") 6e-09) + 0.1))) + (512 * round((value(v("/S<9>" ?result "tran") 6e-09) + 0.1))) + (1024 * round((value(v("/S<10>" ?result "tran") 6e-09) + 0.1))) + (2048 * round((value(v("/S<11>" ?result "tran") 6e-09) + 0.1))) + (4096 * round((value(v("/S<12>" ?result "tran") 6e-09) + 0.1))) + (8192 * round((value(v("/S<13>" ?result "tran") 6e-09) + 0.1))) + (16384 * round((value(v("/S<14>" ?result "tran") 6e-09) + 0.1))) + (16384 * round((value(v("/S<15>" ?result "tran") 6e-09) + 0.1))) + (16384 * round((value(v("/S<15>" ?result "tran") 6e-09) + 0.1))) + (16384 * round((value(v("/Cout" ?result "tran") 6e-09) + 0.1))) + (16384 * round((value(v("/Cout" ?result "tran") 6e-09) + 0.1))) + (16384 * round((value(v("/Cout" ?result "tran") 6e-09) + 0.1))) + (16384 * round((value(v("/Cout" ?result "tran") 6e-09) + 0.1)))) - ((1 * round((value(v("/A<0>" ?result "tran") 6e-09) + 0.1))) + (2 * round((value(v("/A<1>" ?result "tran") 6e-09) + 0.1))) + (4 * round((value(v("/A<2>" ?result "tran") 6e-09) + 0.1))) + (8 * round((value(v("/A<3>" ?result "tran") 6e-09) + 0.1))) + (16 * round((value(v("/A<4>" ?result "tran") 6e-09) + 0.1))) + (32 * round((value(v("/A<5>" ?result "tran") 6e-09) + 0.1))) + (64 * round((value(v("/A<6>" ?result "tran") 6e-09) + 0.1))) + (128 * round((value(v("/A<7>" ?result "tran") 6e-09) + 0.1))) + (256 * round((value(v("/A<8>" ?result "tran") 6e-09) + 0.1))) + (512 * round((value(v("/A<9>" ?result "tran") 6e-09) + 0.1))) + (1024 * round((value(v("/A<10>" ?result "tran") 6e-09) + 0.1))) + (2048 * round((value(v("/A<11>" ?result "tran") 6e-09) + 0.1))) + (4096 * round((value(v("/A<12>" ?result "tran") 6e-09) + 0.1))) + (8192 * round((value(v("/A<13>" ?result "tran") 6e-09) + 0.1))) + (16384 * round((value(v("/A<14>" ?result "tran") 6e-09) + 0.1))) + (16384 * round((value(v("/A<15>" ?result "tran") 6e-09) + 0.1))) + (16384 * round((value(v("/A<15>" ?result "tran") 6e-09) + 0.1))) + (1 * round((value(v("/B<0>" ?result "tran") 6e-09) + 0.1))) + (2 * round((value(v("/B<1>" ?result "tran") 6e-09) + 0.1))) + (4 * round((value(v("/B<2>" ?result "tran") 6e-09) + 0.1))) + (8 * round((value(v("/B<3>" ?result "tran") 6e-09) + 0.1))) + (16 * round((value(v("/B<4>" ?result "tran") 6e-09) + 0.1))) + (32 * round((value(v("/B<5>" ?result "tran") 6e-09) + 0.1))) + (64 * round((value(v("/B<6>" ?result "tran") 6e-09) + 0.1))) + (128 * round((value(v("/B<7>" ?result "tran") 6e-09) + 0.1))) + (256 * round((value(v("/B<8>" ?result "tran") 6e-09) + 0.1))) + (512 * round((value(v("/B<9>" ?result "tran") 6e-09) + 0.1))) + (1024 * round((value(v("/B<10>" ?result "tran") 6e-09) + 0.1))) + (2048 * round((value(v("/B<11>" ?result "tran") 6e-09) + 0.1))) + (4096 * round((value(v("/B<12>" ?result "tran") 6e-09) + 0.1))) + (8192 * round((value(v("/B<13>" ?result "tran") 6e-09) + 0.1))) + (16384 * round((value(v("/B<14>" ?result "tran") 6e-09) + 0.1))) + (16384 * round((value(v("/B<15>" ?result "tran") 6e-09) + 0.1))) + (16384 * round((value(v("/B<15>" ?result "tran") 6e-09) + 0.1))) + round((value(v("/Cin" ?result "tran") 6e-09) + 0.1))))
  Output E8 = (((1 * round((value(v("/S<0>" ?result "tran") 8e-09) + 0.1))) + (2 * round((value(v("/S<1>" ?result "tran") 8e-09) + 0.1))) + (4 * round((value(v("/S<2>" ?result "tran") 8e-09) + 0.1))) + (8 * round((value(v("/S<3>" ?result "tran") 8e-09) + 0.1))) + (16 * round((value(v("/S<4>" ?result "tran") 8e-09) + 0.1))) + (32 * round((value(v("/S<5>" ?result "tran") 8e-09) + 0.1))) + (64 * round((value(v("/S<6>" ?result "tran") 8e-09) + 0.1))) + (128 * round((value(v("/S<7>" ?result "tran") 8e-09) + 0.1))) + (256 * round((value(v("/S<8>" ?result "tran") 8e-09) + 0.1))) + (512 * round((value(v("/S<9>" ?result "tran") 8e-09) + 0.1))) + (1024 * round((value(v("/S<10>" ?result "tran") 8e-09) + 0.1))) + (2048 * round((value(v("/S<11>" ?result "tran") 8e-09) + 0.1))) + (4096 * round((value(v("/S<12>" ?result "tran") 8e-09) + 0.1))) + (8192 * round((value(v("/S<13>" ?result "tran") 8e-09) + 0.1))) + (16384 * round((value(v("/S<14>" ?result "tran") 8e-09) + 0.1))) + (16384 * round((value(v("/S<15>" ?result "tran") 8e-09) + 0.1))) + (16384 * round((value(v("/S<15>" ?result "tran") 8e-09) + 0.1))) + (16384 * round((value(v("/Cout" ?result "tran") 8e-09) + 0.1))) + (16384 * round((value(v("/Cout" ?result "tran") 8e-09) + 0.1))) + (16384 * round((value(v("/Cout" ?result "tran") 8e-09) + 0.1))) + (16384 * round((value(v("/Cout" ?result "tran") 8e-09) + 0.1)))) - ((1 * round((value(v("/A<0>" ?result "tran") 8e-09) + 0.1))) + (2 * round((value(v("/A<1>" ?result "tran") 8e-09) + 0.1))) + (4 * round((value(v("/A<2>" ?result "tran") 8e-09) + 0.1))) + (8 * round((value(v("/A<3>" ?result "tran") 8e-09) + 0.1))) + (16 * round((value(v("/A<4>" ?result "tran") 8e-09) + 0.1))) + (32 * round((value(v("/A<5>" ?result "tran") 8e-09) + 0.1))) + (64 * round((value(v("/A<6>" ?result "tran") 8e-09) + 0.1))) + (128 * round((value(v("/A<7>" ?result "tran") 8e-09) + 0.1))) + (256 * round((value(v("/A<8>" ?result "tran") 8e-09) + 0.1))) + (512 * round((value(v("/A<9>" ?result "tran") 8e-09) + 0.1))) + (1024 * round((value(v("/A<10>" ?result "tran") 8e-09) + 0.1))) + (2048 * round((value(v("/A<11>" ?result "tran") 8e-09) + 0.1))) + (4096 * round((value(v("/A<12>" ?result "tran") 8e-09) + 0.1))) + (8192 * round((value(v("/A<13>" ?result "tran") 8e-09) + 0.1))) + (16384 * round((value(v("/A<14>" ?result "tran") 8e-09) + 0.1))) + (16384 * round((value(v("/A<15>" ?result "tran") 8e-09) + 0.1))) + (16384 * round((value(v("/A<15>" ?result "tran") 8e-09) + 0.1))) + (1 * round((value(v("/B<0>" ?result "tran") 8e-09) + 0.1))) + (2 * round((value(v("/B<1>" ?result "tran") 8e-09) + 0.1))) + (4 * round((value(v("/B<2>" ?result "tran") 8e-09) + 0.1))) + (8 * round((value(v("/B<3>" ?result "tran") 8e-09) + 0.1))) + (16 * round((value(v("/B<4>" ?result "tran") 8e-09) + 0.1))) + (32 * round((value(v("/B<5>" ?result "tran") 8e-09) + 0.1))) + (64 * round((value(v("/B<6>" ?result "tran") 8e-09) + 0.1))) + (128 * round((value(v("/B<7>" ?result "tran") 8e-09) + 0.1))) + (256 * round((value(v("/B<8>" ?result "tran") 8e-09) + 0.1))) + (512 * round((value(v("/B<9>" ?result "tran") 8e-09) + 0.1))) + (1024 * round((value(v("/B<10>" ?result "tran") 8e-09) + 0.1))) + (2048 * round((value(v("/B<11>" ?result "tran") 8e-09) + 0.1))) + (4096 * round((value(v("/B<12>" ?result "tran") 8e-09) + 0.1))) + (8192 * round((value(v("/B<13>" ?result "tran") 8e-09) + 0.1))) + (16384 * round((value(v("/B<14>" ?result "tran") 8e-09) + 0.1))) + (16384 * round((value(v("/B<15>" ?result "tran") 8e-09) + 0.1))) + (16384 * round((value(v("/B<15>" ?result "tran") 8e-09) + 0.1))) + round((value(v("/Cin" ?result "tran") 8e-09) + 0.1))))
  Output E9 = (((1 * round((value(v("/S<0>" ?result "tran") 1e-08) + 0.1))) + (2 * round((value(v("/S<1>" ?result "tran") 1e-08) + 0.1))) + (4 * round((value(v("/S<2>" ?result "tran") 1e-08) + 0.1))) + (8 * round((value(v("/S<3>" ?result "tran") 1e-08) + 0.1))) + (16 * round((value(v("/S<4>" ?result "tran") 1e-08) + 0.1))) + (32 * round((value(v("/S<5>" ?result "tran") 1e-08) + 0.1))) + (64 * round((value(v("/S<6>" ?result "tran") 1e-08) + 0.1))) + (128 * round((value(v("/S<7>" ?result "tran") 1e-08) + 0.1))) + (256 * round((value(v("/S<8>" ?result "tran") 1e-08) + 0.1))) + (512 * round((value(v("/S<9>" ?result "tran") 1e-08) + 0.1))) + (1024 * round((value(v("/S<10>" ?result "tran") 1e-08) + 0.1))) + (2048 * round((value(v("/S<11>" ?result "tran") 1e-08) + 0.1))) + (4096 * round((value(v("/S<12>" ?result "tran") 1e-08) + 0.1))) + (8192 * round((value(v("/S<13>" ?result "tran") 1e-08) + 0.1))) + (16384 * round((value(v("/S<14>" ?result "tran") 1e-08) + 0.1))) + (16384 * round((value(v("/S<15>" ?result "tran") 1e-08) + 0.1))) + (16384 * round((value(v("/S<15>" ?result "tran") 1e-08) + 0.1))) + (16384 * round((value(v("/Cout" ?result "tran") 1e-08) + 0.1))) + (16384 * round((value(v("/Cout" ?result "tran") 1e-08) + 0.1))) + (16384 * round((value(v("/Cout" ?result "tran") 1e-08) + 0.1))) + (16384 * round((value(v("/Cout" ?result "tran") 1e-08) + 0.1)))) - ((1 * round((value(v("/A<0>" ?result "tran") 1e-08) + 0.1))) + (2 * round((value(v("/A<1>" ?result "tran") 1e-08) + 0.1))) + (4 * round((value(v("/A<2>" ?result "tran") 1e-08) + 0.1))) + (8 * round((value(v("/A<3>" ?result "tran") 1e-08) + 0.1))) + (16 * round((value(v("/A<4>" ?result "tran") 1e-08) + 0.1))) + (32 * round((value(v("/A<5>" ?result "tran") 1e-08) + 0.1))) + (64 * round((value(v("/A<6>" ?result "tran") 1e-08) + 0.1))) + (128 * round((value(v("/A<7>" ?result "tran") 1e-08) + 0.1))) + (256 * round((value(v("/A<8>" ?result "tran") 1e-08) + 0.1))) + (512 * round((value(v("/A<9>" ?result "tran") 1e-08) + 0.1))) + (1024 * round((value(v("/A<10>" ?result "tran") 1e-08) + 0.1))) + (2048 * round((value(v("/A<11>" ?result "tran") 1e-08) + 0.1))) + (4096 * round((value(v("/A<12>" ?result "tran") 1e-08) + 0.1))) + (8192 * round((value(v("/A<13>" ?result "tran") 1e-08) + 0.1))) + (16384 * round((value(v("/A<14>" ?result "tran") 1e-08) + 0.1))) + (16384 * round((value(v("/A<15>" ?result "tran") 1e-08) + 0.1))) + (16384 * round((value(v("/A<15>" ?result "tran") 1e-08) + 0.1))) + (1 * round((value(v("/B<0>" ?result "tran") 1e-08) + 0.1))) + (2 * round((value(v("/B<1>" ?result "tran") 1e-08) + 0.1))) + (4 * round((value(v("/B<2>" ?result "tran") 1e-08) + 0.1))) + (8 * round((value(v("/B<3>" ?result "tran") 1e-08) + 0.1))) + (16 * round((value(v("/B<4>" ?result "tran") 1e-08) + 0.1))) + (32 * round((value(v("/B<5>" ?result "tran") 1e-08) + 0.1))) + (64 * round((value(v("/B<6>" ?result "tran") 1e-08) + 0.1))) + (128 * round((value(v("/B<7>" ?result "tran") 1e-08) + 0.1))) + (256 * round((value(v("/B<8>" ?result "tran") 1e-08) + 0.1))) + (512 * round((value(v("/B<9>" ?result "tran") 1e-08) + 0.1))) + (1024 * round((value(v("/B<10>" ?result "tran") 1e-08) + 0.1))) + (2048 * round((value(v("/B<11>" ?result "tran") 1e-08) + 0.1))) + (4096 * round((value(v("/B<12>" ?result "tran") 1e-08) + 0.1))) + (8192 * round((value(v("/B<13>" ?result "tran") 1e-08) + 0.1))) + (16384 * round((value(v("/B<14>" ?result "tran") 1e-08) + 0.1))) + (16384 * round((value(v("/B<15>" ?result "tran") 1e-08) + 0.1))) + (16384 * round((value(v("/B<15>" ?result "tran") 1e-08) + 0.1))) + round((value(v("/Cin" ?result "tran") 1e-08) + 0.1))))
  Output E10 = (((1 * round((value(v("/S<0>" ?result "tran") 1.2e-08) + 0.1))) + (2 * round((value(v("/S<1>" ?result "tran") 1.2e-08) + 0.1))) + (4 * round((value(v("/S<2>" ?result "tran") 1.2e-08) + 0.1))) + (8 * round((value(v("/S<3>" ?result "tran") 1.2e-08) + 0.1))) + (16 * round((value(v("/S<4>" ?result "tran") 1.2e-08) + 0.1))) + (32 * round((value(v("/S<5>" ?result "tran") 1.2e-08) + 0.1))) + (64 * round((value(v("/S<6>" ?result "tran") 1.2e-08) + 0.1))) + (128 * round((value(v("/S<7>" ?result "tran") 1.2e-08) + 0.1))) + (256 * round((value(v("/S<8>" ?result "tran") 1.2e-08) + 0.1))) + (512 * round((value(v("/S<9>" ?result "tran") 1.2e-08) + 0.1))) + (1024 * round((value(v("/S<10>" ?result "tran") 1.2e-08) + 0.1))) + (2048 * round((value(v("/S<11>" ?result "tran") 1.2e-08) + 0.1))) + (4096 * round((value(v("/S<12>" ?result "tran") 1.2e-08) + 0.1))) + (8192 * round((value(v("/S<13>" ?result "tran") 1.2e-08) + 0.1))) + (16384 * round((value(v("/S<14>" ?result "tran") 1.2e-08) + 0.1))) + (16384 * round((value(v("/S<15>" ?result "tran") 1.2e-08) + 0.1))) + (16384 * round((value(v("/S<15>" ?result "tran") 1.2e-08) + 0.1))) + (16384 * round((value(v("/Cout" ?result "tran") 1.2e-08) + 0.1))) + (16384 * round((value(v("/Cout" ?result "tran") 1.2e-08) + 0.1))) + (16384 * round((value(v("/Cout" ?result "tran") 1.2e-08) + 0.1))) + (16384 * round((value(v("/Cout" ?result "tran") 1.2e-08) + 0.1)))) - ((1 * round((value(v("/A<0>" ?result "tran") 1.2e-08) + 0.1))) + (2 * round((value(v("/A<1>" ?result "tran") 1.2e-08) + 0.1))) + (4 * round((value(v("/A<2>" ?result "tran") 1.2e-08) + 0.1))) + (8 * round((value(v("/A<3>" ?result "tran") 1.2e-08) + 0.1))) + (16 * round((value(v("/A<4>" ?result "tran") 1.2e-08) + 0.1))) + (32 * round((value(v("/A<5>" ?result "tran") 1.2e-08) + 0.1))) + (64 * round((value(v("/A<6>" ?result "tran") 1.2e-08) + 0.1))) + (128 * round((value(v("/A<7>" ?result "tran") 1.2e-08) + 0.1))) + (256 * round((value(v("/A<8>" ?result "tran") 1.2e-08) + 0.1))) + (512 * round((value(v("/A<9>" ?result "tran") 1.2e-08) + 0.1))) + (1024 * round((value(v("/A<10>" ?result "tran") 1.2e-08) + 0.1))) + (2048 * round((value(v("/A<11>" ?result "tran") 1.2e-08) + 0.1))) + (4096 * round((value(v("/A<12>" ?result "tran") 1.2e-08) + 0.1))) + (8192 * round((value(v("/A<13>" ?result "tran") 1.2e-08) + 0.1))) + (16384 * round((value(v("/A<14>" ?result "tran") 1.2e-08) + 0.1))) + (16384 * round((value(v("/A<15>" ?result "tran") 1.2e-08) + 0.1))) + (16384 * round((value(v("/A<15>" ?result "tran") 1.2e-08) + 0.1))) + (1 * round((value(v("/B<0>" ?result "tran") 1.2e-08) + 0.1))) + (2 * round((value(v("/B<1>" ?result "tran") 1.2e-08) + 0.1))) + (4 * round((value(v("/B<2>" ?result "tran") 1.2e-08) + 0.1))) + (8 * round((value(v("/B<3>" ?result "tran") 1.2e-08) + 0.1))) + (16 * round((value(v("/B<4>" ?result "tran") 1.2e-08) + 0.1))) + (32 * round((value(v("/B<5>" ?result "tran") 1.2e-08) + 0.1))) + (64 * round((value(v("/B<6>" ?result "tran") 1.2e-08) + 0.1))) + (128 * round((value(v("/B<7>" ?result "tran") 1.2e-08) + 0.1))) + (256 * round((value(v("/B<8>" ?result "tran") 1.2e-08) + 0.1))) + (512 * round((value(v("/B<9>" ?result "tran") 1.2e-08) + 0.1))) + (1024 * round((value(v("/B<10>" ?result "tran") 1.2e-08) + 0.1))) + (2048 * round((value(v("/B<11>" ?result "tran") 1.2e-08) + 0.1))) + (4096 * round((value(v("/B<12>" ?result "tran") 1.2e-08) + 0.1))) + (8192 * round((value(v("/B<13>" ?result "tran") 1.2e-08) + 0.1))) + (16384 * round((value(v("/B<14>" ?result "tran") 1.2e-08) + 0.1))) + (16384 * round((value(v("/B<15>" ?result "tran") 1.2e-08) + 0.1))) + (16384 * round((value(v("/B<15>" ?result "tran") 1.2e-08) + 0.1))) + round((value(v("/Cin" ?result "tran") 1.2e-08) + 0.1))))
  Output E11 = (((1 * round((value(v("/S<0>" ?result "tran") 1.4e-08) + 0.1))) + (2 * round((value(v("/S<1>" ?result "tran") 1.4e-08) + 0.1))) + (4 * round((value(v("/S<2>" ?result "tran") 1.4e-08) + 0.1))) + (8 * round((value(v("/S<3>" ?result "tran") 1.4e-08) + 0.1))) + (16 * round((value(v("/S<4>" ?result "tran") 1.4e-08) + 0.1))) + (32 * round((value(v("/S<5>" ?result "tran") 1.4e-08) + 0.1))) + (64 * round((value(v("/S<6>" ?result "tran") 1.4e-08) + 0.1))) + (128 * round((value(v("/S<7>" ?result "tran") 1.4e-08) + 0.1))) + (256 * round((value(v("/S<8>" ?result "tran") 1.4e-08) + 0.1))) + (512 * round((value(v("/S<9>" ?result "tran") 1.4e-08) + 0.1))) + (1024 * round((value(v("/S<10>" ?result "tran") 1.4e-08) + 0.1))) + (2048 * round((value(v("/S<11>" ?result "tran") 1.4e-08) + 0.1))) + (4096 * round((value(v("/S<12>" ?result "tran") 1.4e-08) + 0.1))) + (8192 * round((value(v("/S<13>" ?result "tran") 1.4e-08) + 0.1))) + (16384 * round((value(v("/S<14>" ?result "tran") 1.4e-08) + 0.1))) + (16384 * round((value(v("/S<15>" ?result "tran") 1.4e-08) + 0.1))) + (16384 * round((value(v("/S<15>" ?result "tran") 1.4e-08) + 0.1))) + (16384 * round((value(v("/Cout" ?result "tran") 1.4e-08) + 0.1))) + (16384 * round((value(v("/Cout" ?result "tran") 1.4e-08) + 0.1))) + (16384 * round((value(v("/Cout" ?result "tran") 1.4e-08) + 0.1))) + (16384 * round((value(v("/Cout" ?result "tran") 1.4e-08) + 0.1)))) - ((1 * round((value(v("/A<0>" ?result "tran") 1.4e-08) + 0.1))) + (2 * round((value(v("/A<1>" ?result "tran") 1.4e-08) + 0.1))) + (4 * round((value(v("/A<2>" ?result "tran") 1.4e-08) + 0.1))) + (8 * round((value(v("/A<3>" ?result "tran") 1.4e-08) + 0.1))) + (16 * round((value(v("/A<4>" ?result "tran") 1.4e-08) + 0.1))) + (32 * round((value(v("/A<5>" ?result "tran") 1.4e-08) + 0.1))) + (64 * round((value(v("/A<6>" ?result "tran") 1.4e-08) + 0.1))) + (128 * round((value(v("/A<7>" ?result "tran") 1.4e-08) + 0.1))) + (256 * round((value(v("/A<8>" ?result "tran") 1.4e-08) + 0.1))) + (512 * round((value(v("/A<9>" ?result "tran") 1.4e-08) + 0.1))) + (1024 * round((value(v("/A<10>" ?result "tran") 1.4e-08) + 0.1))) + (2048 * round((value(v("/A<11>" ?result "tran") 1.4e-08) + 0.1))) + (4096 * round((value(v("/A<12>" ?result "tran") 1.4e-08) + 0.1))) + (8192 * round((value(v("/A<13>" ?result "tran") 1.4e-08) + 0.1))) + (16384 * round((value(v("/A<14>" ?result "tran") 1.4e-08) + 0.1))) + (16384 * round((value(v("/A<15>" ?result "tran") 1.4e-08) + 0.1))) + (16384 * round((value(v("/A<15>" ?result "tran") 1.4e-08) + 0.1))) + (1 * round((value(v("/B<0>" ?result "tran") 1.4e-08) + 0.1))) + (2 * round((value(v("/B<1>" ?result "tran") 1.4e-08) + 0.1))) + (4 * round((value(v("/B<2>" ?result "tran") 1.4e-08) + 0.1))) + (8 * round((value(v("/B<3>" ?result "tran") 1.4e-08) + 0.1))) + (16 * round((value(v("/B<4>" ?result "tran") 1.4e-08) + 0.1))) + (32 * round((value(v("/B<5>" ?result "tran") 1.4e-08) + 0.1))) + (64 * round((value(v("/B<6>" ?result "tran") 1.4e-08) + 0.1))) + (128 * round((value(v("/B<7>" ?result "tran") 1.4e-08) + 0.1))) + (256 * round((value(v("/B<8>" ?result "tran") 1.4e-08) + 0.1))) + (512 * round((value(v("/B<9>" ?result "tran") 1.4e-08) + 0.1))) + (1024 * round((value(v("/B<10>" ?result "tran") 1.4e-08) + 0.1))) + (2048 * round((value(v("/B<11>" ?result "tran") 1.4e-08) + 0.1))) + (4096 * round((value(v("/B<12>" ?result "tran") 1.4e-08) + 0.1))) + (8192 * round((value(v("/B<13>" ?result "tran") 1.4e-08) + 0.1))) + (16384 * round((value(v("/B<14>" ?result "tran") 1.4e-08) + 0.1))) + (16384 * round((value(v("/B<15>" ?result "tran") 1.4e-08) + 0.1))) + (16384 * round((value(v("/B<15>" ?result "tran") 1.4e-08) + 0.1))) + round((value(v("/Cin" ?result "tran") 1.4e-08) + 0.1))))
  Output E12 = (((1 * round((value(v("/S<0>" ?result "tran") 1.6e-08) + 0.1))) + (2 * round((value(v("/S<1>" ?result "tran") 1.6e-08) + 0.1))) + (4 * round((value(v("/S<2>" ?result "tran") 1.6e-08) + 0.1))) + (8 * round((value(v("/S<3>" ?result "tran") 1.6e-08) + 0.1))) + (16 * round((value(v("/S<4>" ?result "tran") 1.6e-08) + 0.1))) + (32 * round((value(v("/S<5>" ?result "tran") 1.6e-08) + 0.1))) + (64 * round((value(v("/S<6>" ?result "tran") 1.6e-08) + 0.1))) + (128 * round((value(v("/S<7>" ?result "tran") 1.6e-08) + 0.1))) + (256 * round((value(v("/S<8>" ?result "tran") 1.6e-08) + 0.1))) + (512 * round((value(v("/S<9>" ?result "tran") 1.6e-08) + 0.1))) + (1024 * round((value(v("/S<10>" ?result "tran") 1.6e-08) + 0.1))) + (2048 * round((value(v("/S<11>" ?result "tran") 1.6e-08) + 0.1))) + (4096 * round((value(v("/S<12>" ?result "tran") 1.6e-08) + 0.1))) + (8192 * round((value(v("/S<13>" ?result "tran") 1.6e-08) + 0.1))) + (16384 * round((value(v("/S<14>" ?result "tran") 1.6e-08) + 0.1))) + (16384 * round((value(v("/S<15>" ?result "tran") 1.6e-08) + 0.1))) + (16384 * round((value(v("/S<15>" ?result "tran") 1.6e-08) + 0.1))) + (16384 * round((value(v("/Cout" ?result "tran") 1.6e-08) + 0.1))) + (16384 * round((value(v("/Cout" ?result "tran") 1.6e-08) + 0.1))) + (16384 * round((value(v("/Cout" ?result "tran") 1.6e-08) + 0.1))) + (16384 * round((value(v("/Cout" ?result "tran") 1.6e-08) + 0.1)))) - ((1 * round((value(v("/A<0>" ?result "tran") 1.6e-08) + 0.1))) + (2 * round((value(v("/A<1>" ?result "tran") 1.6e-08) + 0.1))) + (4 * round((value(v("/A<2>" ?result "tran") 1.6e-08) + 0.1))) + (8 * round((value(v("/A<3>" ?result "tran") 1.6e-08) + 0.1))) + (16 * round((value(v("/A<4>" ?result "tran") 1.6e-08) + 0.1))) + (32 * round((value(v("/A<5>" ?result "tran") 1.6e-08) + 0.1))) + (64 * round((value(v("/A<6>" ?result "tran") 1.6e-08) + 0.1))) + (128 * round((value(v("/A<7>" ?result "tran") 1.6e-08) + 0.1))) + (256 * round((value(v("/A<8>" ?result "tran") 1.6e-08) + 0.1))) + (512 * round((value(v("/A<9>" ?result "tran") 1.6e-08) + 0.1))) + (1024 * round((value(v("/A<10>" ?result "tran") 1.6e-08) + 0.1))) + (2048 * round((value(v("/A<11>" ?result "tran") 1.6e-08) + 0.1))) + (4096 * round((value(v("/A<12>" ?result "tran") 1.6e-08) + 0.1))) + (8192 * round((value(v("/A<13>" ?result "tran") 1.6e-08) + 0.1))) + (16384 * round((value(v("/A<14>" ?result "tran") 1.6e-08) + 0.1))) + (16384 * round((value(v("/A<15>" ?result "tran") 1.6e-08) + 0.1))) + (16384 * round((value(v("/A<15>" ?result "tran") 1.6e-08) + 0.1))) + (1 * round((value(v("/B<0>" ?result "tran") 1.6e-08) + 0.1))) + (2 * round((value(v("/B<1>" ?result "tran") 1.6e-08) + 0.1))) + (4 * round((value(v("/B<2>" ?result "tran") 1.6e-08) + 0.1))) + (8 * round((value(v("/B<3>" ?result "tran") 1.6e-08) + 0.1))) + (16 * round((value(v("/B<4>" ?result "tran") 1.6e-08) + 0.1))) + (32 * round((value(v("/B<5>" ?result "tran") 1.6e-08) + 0.1))) + (64 * round((value(v("/B<6>" ?result "tran") 1.6e-08) + 0.1))) + (128 * round((value(v("/B<7>" ?result "tran") 1.6e-08) + 0.1))) + (256 * round((value(v("/B<8>" ?result "tran") 1.6e-08) + 0.1))) + (512 * round((value(v("/B<9>" ?result "tran") 1.6e-08) + 0.1))) + (1024 * round((value(v("/B<10>" ?result "tran") 1.6e-08) + 0.1))) + (2048 * round((value(v("/B<11>" ?result "tran") 1.6e-08) + 0.1))) + (4096 * round((value(v("/B<12>" ?result "tran") 1.6e-08) + 0.1))) + (8192 * round((value(v("/B<13>" ?result "tran") 1.6e-08) + 0.1))) + (16384 * round((value(v("/B<14>" ?result "tran") 1.6e-08) + 0.1))) + (16384 * round((value(v("/B<15>" ?result "tran") 1.6e-08) + 0.1))) + (16384 * round((value(v("/B<15>" ?result "tran") 1.6e-08) + 0.1))) + round((value(v("/Cin" ?result "tran") 1.6e-08) + 0.1))))
  Output E13 = (((1 * round((value(v("/S<0>" ?result "tran") 1.8e-08) + 0.1))) + (2 * round((value(v("/S<1>" ?result "tran") 1.8e-08) + 0.1))) + (4 * round((value(v("/S<2>" ?result "tran") 1.8e-08) + 0.1))) + (8 * round((value(v("/S<3>" ?result "tran") 1.8e-08) + 0.1))) + (16 * round((value(v("/S<4>" ?result "tran") 1.8e-08) + 0.1))) + (32 * round((value(v("/S<5>" ?result "tran") 1.8e-08) + 0.1))) + (64 * round((value(v("/S<6>" ?result "tran") 1.8e-08) + 0.1))) + (128 * round((value(v("/S<7>" ?result "tran") 1.8e-08) + 0.1))) + (256 * round((value(v("/S<8>" ?result "tran") 1.8e-08) + 0.1))) + (512 * round((value(v("/S<9>" ?result "tran") 1.8e-08) + 0.1))) + (1024 * round((value(v("/S<10>" ?result "tran") 1.8e-08) + 0.1))) + (2048 * round((value(v("/S<11>" ?result "tran") 1.8e-08) + 0.1))) + (4096 * round((value(v("/S<12>" ?result "tran") 1.8e-08) + 0.1))) + (8192 * round((value(v("/S<13>" ?result "tran") 1.8e-08) + 0.1))) + (16384 * round((value(v("/S<14>" ?result "tran") 1.8e-08) + 0.1))) + (16384 * round((value(v("/S<15>" ?result "tran") 1.8e-08) + 0.1))) + (16384 * round((value(v("/S<15>" ?result "tran") 1.8e-08) + 0.1))) + (16384 * round((value(v("/Cout" ?result "tran") 1.8e-08) + 0.1))) + (16384 * round((value(v("/Cout" ?result "tran") 1.8e-08) + 0.1))) + (16384 * round((value(v("/Cout" ?result "tran") 1.8e-08) + 0.1))) + (16384 * round((value(v("/Cout" ?result "tran") 1.8e-08) + 0.1)))) - ((1 * round((value(v("/A<0>" ?result "tran") 1.8e-08) + 0.1))) + (2 * round((value(v("/A<1>" ?result "tran") 1.8e-08) + 0.1))) + (4 * round((value(v("/A<2>" ?result "tran") 1.8e-08) + 0.1))) + (8 * round((value(v("/A<3>" ?result "tran") 1.8e-08) + 0.1))) + (16 * round((value(v("/A<4>" ?result "tran") 1.8e-08) + 0.1))) + (32 * round((value(v("/A<5>" ?result "tran") 1.8e-08) + 0.1))) + (64 * round((value(v("/A<6>" ?result "tran") 1.8e-08) + 0.1))) + (128 * round((value(v("/A<7>" ?result "tran") 1.8e-08) + 0.1))) + (256 * round((value(v("/A<8>" ?result "tran") 1.8e-08) + 0.1))) + (512 * round((value(v("/A<9>" ?result "tran") 1.8e-08) + 0.1))) + (1024 * round((value(v("/A<10>" ?result "tran") 1.8e-08) + 0.1))) + (2048 * round((value(v("/A<11>" ?result "tran") 1.8e-08) + 0.1))) + (4096 * round((value(v("/A<12>" ?result "tran") 1.8e-08) + 0.1))) + (8192 * round((value(v("/A<13>" ?result "tran") 1.8e-08) + 0.1))) + (16384 * round((value(v("/A<14>" ?result "tran") 1.8e-08) + 0.1))) + (16384 * round((value(v("/A<15>" ?result "tran") 1.8e-08) + 0.1))) + (16384 * round((value(v("/A<15>" ?result "tran") 1.8e-08) + 0.1))) + (1 * round((value(v("/B<0>" ?result "tran") 1.8e-08) + 0.1))) + (2 * round((value(v("/B<1>" ?result "tran") 1.8e-08) + 0.1))) + (4 * round((value(v("/B<2>" ?result "tran") 1.8e-08) + 0.1))) + (8 * round((value(v("/B<3>" ?result "tran") 1.8e-08) + 0.1))) + (16 * round((value(v("/B<4>" ?result "tran") 1.8e-08) + 0.1))) + (32 * round((value(v("/B<5>" ?result "tran") 1.8e-08) + 0.1))) + (64 * round((value(v("/B<6>" ?result "tran") 1.8e-08) + 0.1))) + (128 * round((value(v("/B<7>" ?result "tran") 1.8e-08) + 0.1))) + (256 * round((value(v("/B<8>" ?result "tran") 1.8e-08) + 0.1))) + (512 * round((value(v("/B<9>" ?result "tran") 1.8e-08) + 0.1))) + (1024 * round((value(v("/B<10>" ?result "tran") 1.8e-08) + 0.1))) + (2048 * round((value(v("/B<11>" ?result "tran") 1.8e-08) + 0.1))) + (4096 * round((value(v("/B<12>" ?result "tran") 1.8e-08) + 0.1))) + (8192 * round((value(v("/B<13>" ?result "tran") 1.8e-08) + 0.1))) + (16384 * round((value(v("/B<14>" ?result "tran") 1.8e-08) + 0.1))) + (16384 * round((value(v("/B<15>" ?result "tran") 1.8e-08) + 0.1))) + (16384 * round((value(v("/B<15>" ?result "tran") 1.8e-08) + 0.1))) + round((value(v("/Cin" ?result "tran") 1.8e-08) + 0.1))))
  Output E14 = (((1 * round((value(v("/S<0>" ?result "tran") 2e-08) + 0.1))) + (2 * round((value(v("/S<1>" ?result "tran") 2e-08) + 0.1))) + (4 * round((value(v("/S<2>" ?result "tran") 2e-08) + 0.1))) + (8 * round((value(v("/S<3>" ?result "tran") 2e-08) + 0.1))) + (16 * round((value(v("/S<4>" ?result "tran") 2e-08) + 0.1))) + (32 * round((value(v("/S<5>" ?result "tran") 2e-08) + 0.1))) + (64 * round((value(v("/S<6>" ?result "tran") 2e-08) + 0.1))) + (128 * round((value(v("/S<7>" ?result "tran") 2e-08) + 0.1))) + (256 * round((value(v("/S<8>" ?result "tran") 2e-08) + 0.1))) + (512 * round((value(v("/S<9>" ?result "tran") 2e-08) + 0.1))) + (1024 * round((value(v("/S<10>" ?result "tran") 2e-08) + 0.1))) + (2048 * round((value(v("/S<11>" ?result "tran") 2e-08) + 0.1))) + (4096 * round((value(v("/S<12>" ?result "tran") 2e-08) + 0.1))) + (8192 * round((value(v("/S<13>" ?result "tran") 2e-08) + 0.1))) + (16384 * round((value(v("/S<14>" ?result "tran") 2e-08) + 0.1))) + (16384 * round((value(v("/S<15>" ?result "tran") 2e-08) + 0.1))) + (16384 * round((value(v("/S<15>" ?result "tran") 2e-08) + 0.1))) + (16384 * round((value(v("/Cout" ?result "tran") 2e-08) + 0.1))) + (16384 * round((value(v("/Cout" ?result "tran") 2e-08) + 0.1))) + (16384 * round((value(v("/Cout" ?result "tran") 2e-08) + 0.1))) + (16384 * round((value(v("/Cout" ?result "tran") 2e-08) + 0.1)))) - ((1 * round((value(v("/A<0>" ?result "tran") 2e-08) + 0.1))) + (2 * round((value(v("/A<1>" ?result "tran") 2e-08) + 0.1))) + (4 * round((value(v("/A<2>" ?result "tran") 2e-08) + 0.1))) + (8 * round((value(v("/A<3>" ?result "tran") 2e-08) + 0.1))) + (16 * round((value(v("/A<4>" ?result "tran") 2e-08) + 0.1))) + (32 * round((value(v("/A<5>" ?result "tran") 2e-08) + 0.1))) + (64 * round((value(v("/A<6>" ?result "tran") 2e-08) + 0.1))) + (128 * round((value(v("/A<7>" ?result "tran") 2e-08) + 0.1))) + (256 * round((value(v("/A<8>" ?result "tran") 2e-08) + 0.1))) + (512 * round((value(v("/A<9>" ?result "tran") 2e-08) + 0.1))) + (1024 * round((value(v("/A<10>" ?result "tran") 2e-08) + 0.1))) + (2048 * round((value(v("/A<11>" ?result "tran") 2e-08) + 0.1))) + (4096 * round((value(v("/A<12>" ?result "tran") 2e-08) + 0.1))) + (8192 * round((value(v("/A<13>" ?result "tran") 2e-08) + 0.1))) + (16384 * round((value(v("/A<14>" ?result "tran") 2e-08) + 0.1))) + (16384 * round((value(v("/A<15>" ?result "tran") 2e-08) + 0.1))) + (16384 * round((value(v("/A<15>" ?result "tran") 2e-08) + 0.1))) + (1 * round((value(v("/B<0>" ?result "tran") 2e-08) + 0.1))) + (2 * round((value(v("/B<1>" ?result "tran") 2e-08) + 0.1))) + (4 * round((value(v("/B<2>" ?result "tran") 2e-08) + 0.1))) + (8 * round((value(v("/B<3>" ?result "tran") 2e-08) + 0.1))) + (16 * round((value(v("/B<4>" ?result "tran") 2e-08) + 0.1))) + (32 * round((value(v("/B<5>" ?result "tran") 2e-08) + 0.1))) + (64 * round((value(v("/B<6>" ?result "tran") 2e-08) + 0.1))) + (128 * round((value(v("/B<7>" ?result "tran") 2e-08) + 0.1))) + (256 * round((value(v("/B<8>" ?result "tran") 2e-08) + 0.1))) + (512 * round((value(v("/B<9>" ?result "tran") 2e-08) + 0.1))) + (1024 * round((value(v("/B<10>" ?result "tran") 2e-08) + 0.1))) + (2048 * round((value(v("/B<11>" ?result "tran") 2e-08) + 0.1))) + (4096 * round((value(v("/B<12>" ?result "tran") 2e-08) + 0.1))) + (8192 * round((value(v("/B<13>" ?result "tran") 2e-08) + 0.1))) + (16384 * round((value(v("/B<14>" ?result "tran") 2e-08) + 0.1))) + (16384 * round((value(v("/B<15>" ?result "tran") 2e-08) + 0.1))) + (16384 * round((value(v("/B<15>" ?result "tran") 2e-08) + 0.1))) + round((value(v("/Cin" ?result "tran") 2e-08) + 0.1))))
  Output E15 = (((1 * round((value(v("/S<0>" ?result "tran") 2.2e-08) + 0.1))) + (2 * round((value(v("/S<1>" ?result "tran") 2.2e-08) + 0.1))) + (4 * round((value(v("/S<2>" ?result "tran") 2.2e-08) + 0.1))) + (8 * round((value(v("/S<3>" ?result "tran") 2.2e-08) + 0.1))) + (16 * round((value(v("/S<4>" ?result "tran") 2.2e-08) + 0.1))) + (32 * round((value(v("/S<5>" ?result "tran") 2.2e-08) + 0.1))) + (64 * round((value(v("/S<6>" ?result "tran") 2.2e-08) + 0.1))) + (128 * round((value(v("/S<7>" ?result "tran") 2.2e-08) + 0.1))) + (256 * round((value(v("/S<8>" ?result "tran") 2.2e-08) + 0.1))) + (512 * round((value(v("/S<9>" ?result "tran") 2.2e-08) + 0.1))) + (1024 * round((value(v("/S<10>" ?result "tran") 2.2e-08) + 0.1))) + (2048 * round((value(v("/S<11>" ?result "tran") 2.2e-08) + 0.1))) + (4096 * round((value(v("/S<12>" ?result "tran") 2.2e-08) + 0.1))) + (8192 * round((value(v("/S<13>" ?result "tran") 2.2e-08) + 0.1))) + (16384 * round((value(v("/S<14>" ?result "tran") 2.2e-08) + 0.1))) + (16384 * round((value(v("/S<15>" ?result "tran") 2.2e-08) + 0.1))) + (16384 * round((value(v("/S<15>" ?result "tran") 2.2e-08) + 0.1))) + (16384 * round((value(v("/Cout" ?result "tran") 2.2e-08) + 0.1))) + (16384 * round((value(v("/Cout" ?result "tran") 2.2e-08) + 0.1))) + (16384 * round((value(v("/Cout" ?result "tran") 2.2e-08) + 0.1))) + (16384 * round((value(v("/Cout" ?result "tran") 2.2e-08) + 0.1)))) - ((1 * round((value(v("/A<0>" ?result "tran") 2.2e-08) + 0.1))) + (2 * round((value(v("/A<1>" ?result "tran") 2.2e-08) + 0.1))) + (4 * round((value(v("/A<2>" ?result "tran") 2.2e-08) + 0.1))) + (8 * round((value(v("/A<3>" ?result "tran") 2.2e-08) + 0.1))) + (16 * round((value(v("/A<4>" ?result "tran") 2.2e-08) + 0.1))) + (32 * round((value(v("/A<5>" ?result "tran") 2.2e-08) + 0.1))) + (64 * round((value(v("/A<6>" ?result "tran") 2.2e-08) + 0.1))) + (128 * round((value(v("/A<7>" ?result "tran") 2.2e-08) + 0.1))) + (256 * round((value(v("/A<8>" ?result "tran") 2.2e-08) + 0.1))) + (512 * round((value(v("/A<9>" ?result "tran") 2.2e-08) + 0.1))) + (1024 * round((value(v("/A<10>" ?result "tran") 2.2e-08) + 0.1))) + (2048 * round((value(v("/A<11>" ?result "tran") 2.2e-08) + 0.1))) + (4096 * round((value(v("/A<12>" ?result "tran") 2.2e-08) + 0.1))) + (8192 * round((value(v("/A<13>" ?result "tran") 2.2e-08) + 0.1))) + (16384 * round((value(v("/A<14>" ?result "tran") 2.2e-08) + 0.1))) + (16384 * round((value(v("/A<15>" ?result "tran") 2.2e-08) + 0.1))) + (16384 * round((value(v("/A<15>" ?result "tran") 2.2e-08) + 0.1))) + (1 * round((value(v("/B<0>" ?result "tran") 2.2e-08) + 0.1))) + (2 * round((value(v("/B<1>" ?result "tran") 2.2e-08) + 0.1))) + (4 * round((value(v("/B<2>" ?result "tran") 2.2e-08) + 0.1))) + (8 * round((value(v("/B<3>" ?result "tran") 2.2e-08) + 0.1))) + (16 * round((value(v("/B<4>" ?result "tran") 2.2e-08) + 0.1))) + (32 * round((value(v("/B<5>" ?result "tran") 2.2e-08) + 0.1))) + (64 * round((value(v("/B<6>" ?result "tran") 2.2e-08) + 0.1))) + (128 * round((value(v("/B<7>" ?result "tran") 2.2e-08) + 0.1))) + (256 * round((value(v("/B<8>" ?result "tran") 2.2e-08) + 0.1))) + (512 * round((value(v("/B<9>" ?result "tran") 2.2e-08) + 0.1))) + (1024 * round((value(v("/B<10>" ?result "tran") 2.2e-08) + 0.1))) + (2048 * round((value(v("/B<11>" ?result "tran") 2.2e-08) + 0.1))) + (4096 * round((value(v("/B<12>" ?result "tran") 2.2e-08) + 0.1))) + (8192 * round((value(v("/B<13>" ?result "tran") 2.2e-08) + 0.1))) + (16384 * round((value(v("/B<14>" ?result "tran") 2.2e-08) + 0.1))) + (16384 * round((value(v("/B<15>" ?result "tran") 2.2e-08) + 0.1))) + (16384 * round((value(v("/B<15>" ?result "tran") 2.2e-08) + 0.1))) + round((value(v("/Cin" ?result "tran") 2.2e-08) + 0.1))))
  Output E16 = (((1 * round((value(v("/S<0>" ?result "tran") 2.4e-08) + 0.1))) + (2 * round((value(v("/S<1>" ?result "tran") 2.4e-08) + 0.1))) + (4 * round((value(v("/S<2>" ?result "tran") 2.4e-08) + 0.1))) + (8 * round((value(v("/S<3>" ?result "tran") 2.4e-08) + 0.1))) + (16 * round((value(v("/S<4>" ?result "tran") 2.4e-08) + 0.1))) + (32 * round((value(v("/S<5>" ?result "tran") 2.4e-08) + 0.1))) + (64 * round((value(v("/S<6>" ?result "tran") 2.4e-08) + 0.1))) + (128 * round((value(v("/S<7>" ?result "tran") 2.4e-08) + 0.1))) + (256 * round((value(v("/S<8>" ?result "tran") 2.4e-08) + 0.1))) + (512 * round((value(v("/S<9>" ?result "tran") 2.4e-08) + 0.1))) + (1024 * round((value(v("/S<10>" ?result "tran") 2.4e-08) + 0.1))) + (2048 * round((value(v("/S<11>" ?result "tran") 2.4e-08) + 0.1))) + (4096 * round((value(v("/S<12>" ?result "tran") 2.4e-08) + 0.1))) + (8192 * round((value(v("/S<13>" ?result "tran") 2.4e-08) + 0.1))) + (16384 * round((value(v("/S<14>" ?result "tran") 2.4e-08) + 0.1))) + (16384 * round((value(v("/S<15>" ?result "tran") 2.4e-08) + 0.1))) + (16384 * round((value(v("/S<15>" ?result "tran") 2.4e-08) + 0.1))) + (16384 * round((value(v("/Cout" ?result "tran") 2.4e-08) + 0.1))) + (16384 * round((value(v("/Cout" ?result "tran") 2.4e-08) + 0.1))) + (16384 * round((value(v("/Cout" ?result "tran") 2.4e-08) + 0.1))) + (16384 * round((value(v("/Cout" ?result "tran") 2.4e-08) + 0.1)))) - ((1 * round((value(v("/A<0>" ?result "tran") 2.4e-08) + 0.1))) + (2 * round((value(v("/A<1>" ?result "tran") 2.4e-08) + 0.1))) + (4 * round((value(v("/A<2>" ?result "tran") 2.4e-08) + 0.1))) + (8 * round((value(v("/A<3>" ?result "tran") 2.4e-08) + 0.1))) + (16 * round((value(v("/A<4>" ?result "tran") 2.4e-08) + 0.1))) + (32 * round((value(v("/A<5>" ?result "tran") 2.4e-08) + 0.1))) + (64 * round((value(v("/A<6>" ?result "tran") 2.4e-08) + 0.1))) + (128 * round((value(v("/A<7>" ?result "tran") 2.4e-08) + 0.1))) + (256 * round((value(v("/A<8>" ?result "tran") 2.4e-08) + 0.1))) + (512 * round((value(v("/A<9>" ?result "tran") 2.4e-08) + 0.1))) + (1024 * round((value(v("/A<10>" ?result "tran") 2.4e-08) + 0.1))) + (2048 * round((value(v("/A<11>" ?result "tran") 2.4e-08) + 0.1))) + (4096 * round((value(v("/A<12>" ?result "tran") 2.4e-08) + 0.1))) + (8192 * round((value(v("/A<13>" ?result "tran") 2.4e-08) + 0.1))) + (16384 * round((value(v("/A<14>" ?result "tran") 2.4e-08) + 0.1))) + (16384 * round((value(v("/A<15>" ?result "tran") 2.4e-08) + 0.1))) + (16384 * round((value(v("/A<15>" ?result "tran") 2.4e-08) + 0.1))) + (1 * round((value(v("/B<0>" ?result "tran") 2.4e-08) + 0.1))) + (2 * round((value(v("/B<1>" ?result "tran") 2.4e-08) + 0.1))) + (4 * round((value(v("/B<2>" ?result "tran") 2.4e-08) + 0.1))) + (8 * round((value(v("/B<3>" ?result "tran") 2.4e-08) + 0.1))) + (16 * round((value(v("/B<4>" ?result "tran") 2.4e-08) + 0.1))) + (32 * round((value(v("/B<5>" ?result "tran") 2.4e-08) + 0.1))) + (64 * round((value(v("/B<6>" ?result "tran") 2.4e-08) + 0.1))) + (128 * round((value(v("/B<7>" ?result "tran") 2.4e-08) + 0.1))) + (256 * round((value(v("/B<8>" ?result "tran") 2.4e-08) + 0.1))) + (512 * round((value(v("/B<9>" ?result "tran") 2.4e-08) + 0.1))) + (1024 * round((value(v("/B<10>" ?result "tran") 2.4e-08) + 0.1))) + (2048 * round((value(v("/B<11>" ?result "tran") 2.4e-08) + 0.1))) + (4096 * round((value(v("/B<12>" ?result "tran") 2.4e-08) + 0.1))) + (8192 * round((value(v("/B<13>" ?result "tran") 2.4e-08) + 0.1))) + (16384 * round((value(v("/B<14>" ?result "tran") 2.4e-08) + 0.1))) + (16384 * round((value(v("/B<15>" ?result "tran") 2.4e-08) + 0.1))) + (16384 * round((value(v("/B<15>" ?result "tran") 2.4e-08) + 0.1))) + round((value(v("/Cin" ?result "tran") 2.4e-08) + 0.1))))
  Output E17 = (((1 * round((value(v("/S<0>" ?result "tran") 2.6e-08) + 0.1))) + (2 * round((value(v("/S<1>" ?result "tran") 2.6e-08) + 0.1))) + (4 * round((value(v("/S<2>" ?result "tran") 2.6e-08) + 0.1))) + (8 * round((value(v("/S<3>" ?result "tran") 2.6e-08) + 0.1))) + (16 * round((value(v("/S<4>" ?result "tran") 2.6e-08) + 0.1))) + (32 * round((value(v("/S<5>" ?result "tran") 2.6e-08) + 0.1))) + (64 * round((value(v("/S<6>" ?result "tran") 2.6e-08) + 0.1))) + (128 * round((value(v("/S<7>" ?result "tran") 2.6e-08) + 0.1))) + (256 * round((value(v("/S<8>" ?result "tran") 2.6e-08) + 0.1))) + (512 * round((value(v("/S<9>" ?result "tran") 2.6e-08) + 0.1))) + (1024 * round((value(v("/S<10>" ?result "tran") 2.6e-08) + 0.1))) + (2048 * round((value(v("/S<11>" ?result "tran") 2.6e-08) + 0.1))) + (4096 * round((value(v("/S<12>" ?result "tran") 2.6e-08) + 0.1))) + (8192 * round((value(v("/S<13>" ?result "tran") 2.6e-08) + 0.1))) + (16384 * round((value(v("/S<14>" ?result "tran") 2.6e-08) + 0.1))) + (16384 * round((value(v("/S<15>" ?result "tran") 2.6e-08) + 0.1))) + (16384 * round((value(v("/S<15>" ?result "tran") 2.6e-08) + 0.1))) + (16384 * round((value(v("/Cout" ?result "tran") 2.6e-08) + 0.1))) + (16384 * round((value(v("/Cout" ?result "tran") 2.6e-08) + 0.1))) + (16384 * round((value(v("/Cout" ?result "tran") 2.6e-08) + 0.1))) + (16384 * round((value(v("/Cout" ?result "tran") 2.6e-08) + 0.1)))) - ((1 * round((value(v("/A<0>" ?result "tran") 2.6e-08) + 0.1))) + (2 * round((value(v("/A<1>" ?result "tran") 2.6e-08) + 0.1))) + (4 * round((value(v("/A<2>" ?result "tran") 2.6e-08) + 0.1))) + (8 * round((value(v("/A<3>" ?result "tran") 2.6e-08) + 0.1))) + (16 * round((value(v("/A<4>" ?result "tran") 2.6e-08) + 0.1))) + (32 * round((value(v("/A<5>" ?result "tran") 2.6e-08) + 0.1))) + (64 * round((value(v("/A<6>" ?result "tran") 2.6e-08) + 0.1))) + (128 * round((value(v("/A<7>" ?result "tran") 2.6e-08) + 0.1))) + (256 * round((value(v("/A<8>" ?result "tran") 2.6e-08) + 0.1))) + (512 * round((value(v("/A<9>" ?result "tran") 2.6e-08) + 0.1))) + (1024 * round((value(v("/A<10>" ?result "tran") 2.6e-08) + 0.1))) + (2048 * round((value(v("/A<11>" ?result "tran") 2.6e-08) + 0.1))) + (4096 * round((value(v("/A<12>" ?result "tran") 2.6e-08) + 0.1))) + (8192 * round((value(v("/A<13>" ?result "tran") 2.6e-08) + 0.1))) + (16384 * round((value(v("/A<14>" ?result "tran") 2.6e-08) + 0.1))) + (16384 * round((value(v("/A<15>" ?result "tran") 2.6e-08) + 0.1))) + (16384 * round((value(v("/A<15>" ?result "tran") 2.6e-08) + 0.1))) + (1 * round((value(v("/B<0>" ?result "tran") 2.6e-08) + 0.1))) + (2 * round((value(v("/B<1>" ?result "tran") 2.6e-08) + 0.1))) + (4 * round((value(v("/B<2>" ?result "tran") 2.6e-08) + 0.1))) + (8 * round((value(v("/B<3>" ?result "tran") 2.6e-08) + 0.1))) + (16 * round((value(v("/B<4>" ?result "tran") 2.6e-08) + 0.1))) + (32 * round((value(v("/B<5>" ?result "tran") 2.6e-08) + 0.1))) + (64 * round((value(v("/B<6>" ?result "tran") 2.6e-08) + 0.1))) + (128 * round((value(v("/B<7>" ?result "tran") 2.6e-08) + 0.1))) + (256 * round((value(v("/B<8>" ?result "tran") 2.6e-08) + 0.1))) + (512 * round((value(v("/B<9>" ?result "tran") 2.6e-08) + 0.1))) + (1024 * round((value(v("/B<10>" ?result "tran") 2.6e-08) + 0.1))) + (2048 * round((value(v("/B<11>" ?result "tran") 2.6e-08) + 0.1))) + (4096 * round((value(v("/B<12>" ?result "tran") 2.6e-08) + 0.1))) + (8192 * round((value(v("/B<13>" ?result "tran") 2.6e-08) + 0.1))) + (16384 * round((value(v("/B<14>" ?result "tran") 2.6e-08) + 0.1))) + (16384 * round((value(v("/B<15>" ?result "tran") 2.6e-08) + 0.1))) + (16384 * round((value(v("/B<15>" ?result "tran") 2.6e-08) + 0.1))) + round((value(v("/Cin" ?result "tran") 2.6e-08) + 0.1))))
  Output E18 = (((1 * round((value(v("/S<0>" ?result "tran") 2.8e-08) + 0.1))) + (2 * round((value(v("/S<1>" ?result "tran") 2.8e-08) + 0.1))) + (4 * round((value(v("/S<2>" ?result "tran") 2.8e-08) + 0.1))) + (8 * round((value(v("/S<3>" ?result "tran") 2.8e-08) + 0.1))) + (16 * round((value(v("/S<4>" ?result "tran") 2.8e-08) + 0.1))) + (32 * round((value(v("/S<5>" ?result "tran") 2.8e-08) + 0.1))) + (64 * round((value(v("/S<6>" ?result "tran") 2.8e-08) + 0.1))) + (128 * round((value(v("/S<7>" ?result "tran") 2.8e-08) + 0.1))) + (256 * round((value(v("/S<8>" ?result "tran") 2.8e-08) + 0.1))) + (512 * round((value(v("/S<9>" ?result "tran") 2.8e-08) + 0.1))) + (1024 * round((value(v("/S<10>" ?result "tran") 2.8e-08) + 0.1))) + (2048 * round((value(v("/S<11>" ?result "tran") 2.8e-08) + 0.1))) + (4096 * round((value(v("/S<12>" ?result "tran") 2.8e-08) + 0.1))) + (8192 * round((value(v("/S<13>" ?result "tran") 2.8e-08) + 0.1))) + (16384 * round((value(v("/S<14>" ?result "tran") 2.8e-08) + 0.1))) + (16384 * round((value(v("/S<15>" ?result "tran") 2.8e-08) + 0.1))) + (16384 * round((value(v("/S<15>" ?result "tran") 2.8e-08) + 0.1))) + (16384 * round((value(v("/Cout" ?result "tran") 2.8e-08) + 0.1))) + (16384 * round((value(v("/Cout" ?result "tran") 2.8e-08) + 0.1))) + (16384 * round((value(v("/Cout" ?result "tran") 2.8e-08) + 0.1))) + (16384 * round((value(v("/Cout" ?result "tran") 2.8e-08) + 0.1)))) - ((1 * round((value(v("/A<0>" ?result "tran") 2.8e-08) + 0.1))) + (2 * round((value(v("/A<1>" ?result "tran") 2.8e-08) + 0.1))) + (4 * round((value(v("/A<2>" ?result "tran") 2.8e-08) + 0.1))) + (8 * round((value(v("/A<3>" ?result "tran") 2.8e-08) + 0.1))) + (16 * round((value(v("/A<4>" ?result "tran") 2.8e-08) + 0.1))) + (32 * round((value(v("/A<5>" ?result "tran") 2.8e-08) + 0.1))) + (64 * round((value(v("/A<6>" ?result "tran") 2.8e-08) + 0.1))) + (128 * round((value(v("/A<7>" ?result "tran") 2.8e-08) + 0.1))) + (256 * round((value(v("/A<8>" ?result "tran") 2.8e-08) + 0.1))) + (512 * round((value(v("/A<9>" ?result "tran") 2.8e-08) + 0.1))) + (1024 * round((value(v("/A<10>" ?result "tran") 2.8e-08) + 0.1))) + (2048 * round((value(v("/A<11>" ?result "tran") 2.8e-08) + 0.1))) + (4096 * round((value(v("/A<12>" ?result "tran") 2.8e-08) + 0.1))) + (8192 * round((value(v("/A<13>" ?result "tran") 2.8e-08) + 0.1))) + (16384 * round((value(v("/A<14>" ?result "tran") 2.8e-08) + 0.1))) + (16384 * round((value(v("/A<15>" ?result "tran") 2.8e-08) + 0.1))) + (16384 * round((value(v("/A<15>" ?result "tran") 2.8e-08) + 0.1))) + (1 * round((value(v("/B<0>" ?result "tran") 2.8e-08) + 0.1))) + (2 * round((value(v("/B<1>" ?result "tran") 2.8e-08) + 0.1))) + (4 * round((value(v("/B<2>" ?result "tran") 2.8e-08) + 0.1))) + (8 * round((value(v("/B<3>" ?result "tran") 2.8e-08) + 0.1))) + (16 * round((value(v("/B<4>" ?result "tran") 2.8e-08) + 0.1))) + (32 * round((value(v("/B<5>" ?result "tran") 2.8e-08) + 0.1))) + (64 * round((value(v("/B<6>" ?result "tran") 2.8e-08) + 0.1))) + (128 * round((value(v("/B<7>" ?result "tran") 2.8e-08) + 0.1))) + (256 * round((value(v("/B<8>" ?result "tran") 2.8e-08) + 0.1))) + (512 * round((value(v("/B<9>" ?result "tran") 2.8e-08) + 0.1))) + (1024 * round((value(v("/B<10>" ?result "tran") 2.8e-08) + 0.1))) + (2048 * round((value(v("/B<11>" ?result "tran") 2.8e-08) + 0.1))) + (4096 * round((value(v("/B<12>" ?result "tran") 2.8e-08) + 0.1))) + (8192 * round((value(v("/B<13>" ?result "tran") 2.8e-08) + 0.1))) + (16384 * round((value(v("/B<14>" ?result "tran") 2.8e-08) + 0.1))) + (16384 * round((value(v("/B<15>" ?result "tran") 2.8e-08) + 0.1))) + (16384 * round((value(v("/B<15>" ?result "tran") 2.8e-08) + 0.1))) + round((value(v("/Cin" ?result "tran") 2.8e-08) + 0.1))))
  Output E19 = (((1 * round((value(v("/S<0>" ?result "tran") 3e-08) + 0.1))) + (2 * round((value(v("/S<1>" ?result "tran") 3e-08) + 0.1))) + (4 * round((value(v("/S<2>" ?result "tran") 3e-08) + 0.1))) + (8 * round((value(v("/S<3>" ?result "tran") 3e-08) + 0.1))) + (16 * round((value(v("/S<4>" ?result "tran") 3e-08) + 0.1))) + (32 * round((value(v("/S<5>" ?result "tran") 3e-08) + 0.1))) + (64 * round((value(v("/S<6>" ?result "tran") 3e-08) + 0.1))) + (128 * round((value(v("/S<7>" ?result "tran") 3e-08) + 0.1))) + (256 * round((value(v("/S<8>" ?result "tran") 3e-08) + 0.1))) + (512 * round((value(v("/S<9>" ?result "tran") 3e-08) + 0.1))) + (1024 * round((value(v("/S<10>" ?result "tran") 3e-08) + 0.1))) + (2048 * round((value(v("/S<11>" ?result "tran") 3e-08) + 0.1))) + (4096 * round((value(v("/S<12>" ?result "tran") 3e-08) + 0.1))) + (8192 * round((value(v("/S<13>" ?result "tran") 3e-08) + 0.1))) + (16384 * round((value(v("/S<14>" ?result "tran") 3e-08) + 0.1))) + (16384 * round((value(v("/S<15>" ?result "tran") 3e-08) + 0.1))) + (16384 * round((value(v("/S<15>" ?result "tran") 3e-08) + 0.1))) + (16384 * round((value(v("/Cout" ?result "tran") 3e-08) + 0.1))) + (16384 * round((value(v("/Cout" ?result "tran") 3e-08) + 0.1))) + (16384 * round((value(v("/Cout" ?result "tran") 3e-08) + 0.1))) + (16384 * round((value(v("/Cout" ?result "tran") 3e-08) + 0.1)))) - ((1 * round((value(v("/A<0>" ?result "tran") 3e-08) + 0.1))) + (2 * round((value(v("/A<1>" ?result "tran") 3e-08) + 0.1))) + (4 * round((value(v("/A<2>" ?result "tran") 3e-08) + 0.1))) + (8 * round((value(v("/A<3>" ?result "tran") 3e-08) + 0.1))) + (16 * round((value(v("/A<4>" ?result "tran") 3e-08) + 0.1))) + (32 * round((value(v("/A<5>" ?result "tran") 3e-08) + 0.1))) + (64 * round((value(v("/A<6>" ?result "tran") 3e-08) + 0.1))) + (128 * round((value(v("/A<7>" ?result "tran") 3e-08) + 0.1))) + (256 * round((value(v("/A<8>" ?result "tran") 3e-08) + 0.1))) + (512 * round((value(v("/A<9>" ?result "tran") 3e-08) + 0.1))) + (1024 * round((value(v("/A<10>" ?result "tran") 3e-08) + 0.1))) + (2048 * round((value(v("/A<11>" ?result "tran") 3e-08) + 0.1))) + (4096 * round((value(v("/A<12>" ?result "tran") 3e-08) + 0.1))) + (8192 * round((value(v("/A<13>" ?result "tran") 3e-08) + 0.1))) + (16384 * round((value(v("/A<14>" ?result "tran") 3e-08) + 0.1))) + (16384 * round((value(v("/A<15>" ?result "tran") 3e-08) + 0.1))) + (16384 * round((value(v("/A<15>" ?result "tran") 3e-08) + 0.1))) + (1 * round((value(v("/B<0>" ?result "tran") 3e-08) + 0.1))) + (2 * round((value(v("/B<1>" ?result "tran") 3e-08) + 0.1))) + (4 * round((value(v("/B<2>" ?result "tran") 3e-08) + 0.1))) + (8 * round((value(v("/B<3>" ?result "tran") 3e-08) + 0.1))) + (16 * round((value(v("/B<4>" ?result "tran") 3e-08) + 0.1))) + (32 * round((value(v("/B<5>" ?result "tran") 3e-08) + 0.1))) + (64 * round((value(v("/B<6>" ?result "tran") 3e-08) + 0.1))) + (128 * round((value(v("/B<7>" ?result "tran") 3e-08) + 0.1))) + (256 * round((value(v("/B<8>" ?result "tran") 3e-08) + 0.1))) + (512 * round((value(v("/B<9>" ?result "tran") 3e-08) + 0.1))) + (1024 * round((value(v("/B<10>" ?result "tran") 3e-08) + 0.1))) + (2048 * round((value(v("/B<11>" ?result "tran") 3e-08) + 0.1))) + (4096 * round((value(v("/B<12>" ?result "tran") 3e-08) + 0.1))) + (8192 * round((value(v("/B<13>" ?result "tran") 3e-08) + 0.1))) + (16384 * round((value(v("/B<14>" ?result "tran") 3e-08) + 0.1))) + (16384 * round((value(v("/B<15>" ?result "tran") 3e-08) + 0.1))) + (16384 * round((value(v("/B<15>" ?result "tran") 3e-08) + 0.1))) + round((value(v("/Cin" ?result "tran") 3e-08) + 0.1))))
  Output E20 = (((1 * round((value(v("/S<0>" ?result "tran") 3.2e-08) + 0.1))) + (2 * round((value(v("/S<1>" ?result "tran") 3.2e-08) + 0.1))) + (4 * round((value(v("/S<2>" ?result "tran") 3.2e-08) + 0.1))) + (8 * round((value(v("/S<3>" ?result "tran") 3.2e-08) + 0.1))) + (16 * round((value(v("/S<4>" ?result "tran") 3.2e-08) + 0.1))) + (32 * round((value(v("/S<5>" ?result "tran") 3.2e-08) + 0.1))) + (64 * round((value(v("/S<6>" ?result "tran") 3.2e-08) + 0.1))) + (128 * round((value(v("/S<7>" ?result "tran") 3.2e-08) + 0.1))) + (256 * round((value(v("/S<8>" ?result "tran") 3.2e-08) + 0.1))) + (512 * round((value(v("/S<9>" ?result "tran") 3.2e-08) + 0.1))) + (1024 * round((value(v("/S<10>" ?result "tran") 3.2e-08) + 0.1))) + (2048 * round((value(v("/S<11>" ?result "tran") 3.2e-08) + 0.1))) + (4096 * round((value(v("/S<12>" ?result "tran") 3.2e-08) + 0.1))) + (8192 * round((value(v("/S<13>" ?result "tran") 3.2e-08) + 0.1))) + (16384 * round((value(v("/S<14>" ?result "tran") 3.2e-08) + 0.1))) + (16384 * round((value(v("/S<15>" ?result "tran") 3.2e-08) + 0.1))) + (16384 * round((value(v("/S<15>" ?result "tran") 3.2e-08) + 0.1))) + (16384 * round((value(v("/Cout" ?result "tran") 3.2e-08) + 0.1))) + (16384 * round((value(v("/Cout" ?result "tran") 3.2e-08) + 0.1))) + (16384 * round((value(v("/Cout" ?result "tran") 3.2e-08) + 0.1))) + (16384 * round((value(v("/Cout" ?result "tran") 3.2e-08) + 0.1)))) - ((1 * round((value(v("/A<0>" ?result "tran") 3.2e-08) + 0.1))) + (2 * round((value(v("/A<1>" ?result "tran") 3.2e-08) + 0.1))) + (4 * round((value(v("/A<2>" ?result "tran") 3.2e-08) + 0.1))) + (8 * round((value(v("/A<3>" ?result "tran") 3.2e-08) + 0.1))) + (16 * round((value(v("/A<4>" ?result "tran") 3.2e-08) + 0.1))) + (32 * round((value(v("/A<5>" ?result "tran") 3.2e-08) + 0.1))) + (64 * round((value(v("/A<6>" ?result "tran") 3.2e-08) + 0.1))) + (128 * round((value(v("/A<7>" ?result "tran") 3.2e-08) + 0.1))) + (256 * round((value(v("/A<8>" ?result "tran") 3.2e-08) + 0.1))) + (512 * round((value(v("/A<9>" ?result "tran") 3.2e-08) + 0.1))) + (1024 * round((value(v("/A<10>" ?result "tran") 3.2e-08) + 0.1))) + (2048 * round((value(v("/A<11>" ?result "tran") 3.2e-08) + 0.1))) + (4096 * round((value(v("/A<12>" ?result "tran") 3.2e-08) + 0.1))) + (8192 * round((value(v("/A<13>" ?result "tran") 3.2e-08) + 0.1))) + (16384 * round((value(v("/A<14>" ?result "tran") 3.2e-08) + 0.1))) + (16384 * round((value(v("/A<15>" ?result "tran") 3.2e-08) + 0.1))) + (16384 * round((value(v("/A<15>" ?result "tran") 3.2e-08) + 0.1))) + (1 * round((value(v("/B<0>" ?result "tran") 3.2e-08) + 0.1))) + (2 * round((value(v("/B<1>" ?result "tran") 3.2e-08) + 0.1))) + (4 * round((value(v("/B<2>" ?result "tran") 3.2e-08) + 0.1))) + (8 * round((value(v("/B<3>" ?result "tran") 3.2e-08) + 0.1))) + (16 * round((value(v("/B<4>" ?result "tran") 3.2e-08) + 0.1))) + (32 * round((value(v("/B<5>" ?result "tran") 3.2e-08) + 0.1))) + (64 * round((value(v("/B<6>" ?result "tran") 3.2e-08) + 0.1))) + (128 * round((value(v("/B<7>" ?result "tran") 3.2e-08) + 0.1))) + (256 * round((value(v("/B<8>" ?result "tran") 3.2e-08) + 0.1))) + (512 * round((value(v("/B<9>" ?result "tran") 3.2e-08) + 0.1))) + (1024 * round((value(v("/B<10>" ?result "tran") 3.2e-08) + 0.1))) + (2048 * round((value(v("/B<11>" ?result "tran") 3.2e-08) + 0.1))) + (4096 * round((value(v("/B<12>" ?result "tran") 3.2e-08) + 0.1))) + (8192 * round((value(v("/B<13>" ?result "tran") 3.2e-08) + 0.1))) + (16384 * round((value(v("/B<14>" ?result "tran") 3.2e-08) + 0.1))) + (16384 * round((value(v("/B<15>" ?result "tran") 3.2e-08) + 0.1))) + (16384 * round((value(v("/B<15>" ?result "tran") 3.2e-08) + 0.1))) + round((value(v("/Cin" ?result "tran") 3.2e-08) + 0.1))))
  Output E21 = (((1 * round((value(v("/S<0>" ?result "tran") 3.4e-08) + 0.1))) + (2 * round((value(v("/S<1>" ?result "tran") 3.4e-08) + 0.1))) + (4 * round((value(v("/S<2>" ?result "tran") 3.4e-08) + 0.1))) + (8 * round((value(v("/S<3>" ?result "tran") 3.4e-08) + 0.1))) + (16 * round((value(v("/S<4>" ?result "tran") 3.4e-08) + 0.1))) + (32 * round((value(v("/S<5>" ?result "tran") 3.4e-08) + 0.1))) + (64 * round((value(v("/S<6>" ?result "tran") 3.4e-08) + 0.1))) + (128 * round((value(v("/S<7>" ?result "tran") 3.4e-08) + 0.1))) + (256 * round((value(v("/S<8>" ?result "tran") 3.4e-08) + 0.1))) + (512 * round((value(v("/S<9>" ?result "tran") 3.4e-08) + 0.1))) + (1024 * round((value(v("/S<10>" ?result "tran") 3.4e-08) + 0.1))) + (2048 * round((value(v("/S<11>" ?result "tran") 3.4e-08) + 0.1))) + (4096 * round((value(v("/S<12>" ?result "tran") 3.4e-08) + 0.1))) + (8192 * round((value(v("/S<13>" ?result "tran") 3.4e-08) + 0.1))) + (16384 * round((value(v("/S<14>" ?result "tran") 3.4e-08) + 0.1))) + (16384 * round((value(v("/S<15>" ?result "tran") 3.4e-08) + 0.1))) + (16384 * round((value(v("/S<15>" ?result "tran") 3.4e-08) + 0.1))) + (16384 * round((value(v("/Cout" ?result "tran") 3.4e-08) + 0.1))) + (16384 * round((value(v("/Cout" ?result "tran") 3.4e-08) + 0.1))) + (16384 * round((value(v("/Cout" ?result "tran") 3.4e-08) + 0.1))) + (16384 * round((value(v("/Cout" ?result "tran") 3.4e-08) + 0.1)))) - ((1 * round((value(v("/A<0>" ?result "tran") 3.4e-08) + 0.1))) + (2 * round((value(v("/A<1>" ?result "tran") 3.4e-08) + 0.1))) + (4 * round((value(v("/A<2>" ?result "tran") 3.4e-08) + 0.1))) + (8 * round((value(v("/A<3>" ?result "tran") 3.4e-08) + 0.1))) + (16 * round((value(v("/A<4>" ?result "tran") 3.4e-08) + 0.1))) + (32 * round((value(v("/A<5>" ?result "tran") 3.4e-08) + 0.1))) + (64 * round((value(v("/A<6>" ?result "tran") 3.4e-08) + 0.1))) + (128 * round((value(v("/A<7>" ?result "tran") 3.4e-08) + 0.1))) + (256 * round((value(v("/A<8>" ?result "tran") 3.4e-08) + 0.1))) + (512 * round((value(v("/A<9>" ?result "tran") 3.4e-08) + 0.1))) + (1024 * round((value(v("/A<10>" ?result "tran") 3.4e-08) + 0.1))) + (2048 * round((value(v("/A<11>" ?result "tran") 3.4e-08) + 0.1))) + (4096 * round((value(v("/A<12>" ?result "tran") 3.4e-08) + 0.1))) + (8192 * round((value(v("/A<13>" ?result "tran") 3.4e-08) + 0.1))) + (16384 * round((value(v("/A<14>" ?result "tran") 3.4e-08) + 0.1))) + (16384 * round((value(v("/A<15>" ?result "tran") 3.4e-08) + 0.1))) + (16384 * round((value(v("/A<15>" ?result "tran") 3.4e-08) + 0.1))) + (1 * round((value(v("/B<0>" ?result "tran") 3.4e-08) + 0.1))) + (2 * round((value(v("/B<1>" ?result "tran") 3.4e-08) + 0.1))) + (4 * round((value(v("/B<2>" ?result "tran") 3.4e-08) + 0.1))) + (8 * round((value(v("/B<3>" ?result "tran") 3.4e-08) + 0.1))) + (16 * round((value(v("/B<4>" ?result "tran") 3.4e-08) + 0.1))) + (32 * round((value(v("/B<5>" ?result "tran") 3.4e-08) + 0.1))) + (64 * round((value(v("/B<6>" ?result "tran") 3.4e-08) + 0.1))) + (128 * round((value(v("/B<7>" ?result "tran") 3.4e-08) + 0.1))) + (256 * round((value(v("/B<8>" ?result "tran") 3.4e-08) + 0.1))) + (512 * round((value(v("/B<9>" ?result "tran") 3.4e-08) + 0.1))) + (1024 * round((value(v("/B<10>" ?result "tran") 3.4e-08) + 0.1))) + (2048 * round((value(v("/B<11>" ?result "tran") 3.4e-08) + 0.1))) + (4096 * round((value(v("/B<12>" ?result "tran") 3.4e-08) + 0.1))) + (8192 * round((value(v("/B<13>" ?result "tran") 3.4e-08) + 0.1))) + (16384 * round((value(v("/B<14>" ?result "tran") 3.4e-08) + 0.1))) + (16384 * round((value(v("/B<15>" ?result "tran") 3.4e-08) + 0.1))) + (16384 * round((value(v("/B<15>" ?result "tran") 3.4e-08) + 0.1))) + round((value(v("/Cin" ?result "tran") 3.4e-08) + 0.1))))
  Output E22 = (((1 * round((value(v("/S<0>" ?result "tran") 3.6e-08) + 0.1))) + (2 * round((value(v("/S<1>" ?result "tran") 3.6e-08) + 0.1))) + (4 * round((value(v("/S<2>" ?result "tran") 3.6e-08) + 0.1))) + (8 * round((value(v("/S<3>" ?result "tran") 3.6e-08) + 0.1))) + (16 * round((value(v("/S<4>" ?result "tran") 3.6e-08) + 0.1))) + (32 * round((value(v("/S<5>" ?result "tran") 3.6e-08) + 0.1))) + (64 * round((value(v("/S<6>" ?result "tran") 3.6e-08) + 0.1))) + (128 * round((value(v("/S<7>" ?result "tran") 3.6e-08) + 0.1))) + (256 * round((value(v("/S<8>" ?result "tran") 3.6e-08) + 0.1))) + (512 * round((value(v("/S<9>" ?result "tran") 3.6e-08) + 0.1))) + (1024 * round((value(v("/S<10>" ?result "tran") 3.6e-08) + 0.1))) + (2048 * round((value(v("/S<11>" ?result "tran") 3.6e-08) + 0.1))) + (4096 * round((value(v("/S<12>" ?result "tran") 3.6e-08) + 0.1))) + (8192 * round((value(v("/S<13>" ?result "tran") 3.6e-08) + 0.1))) + (16384 * round((value(v("/S<14>" ?result "tran") 3.6e-08) + 0.1))) + (16384 * round((value(v("/S<15>" ?result "tran") 3.6e-08) + 0.1))) + (16384 * round((value(v("/S<15>" ?result "tran") 3.6e-08) + 0.1))) + (16384 * round((value(v("/Cout" ?result "tran") 3.6e-08) + 0.1))) + (16384 * round((value(v("/Cout" ?result "tran") 3.6e-08) + 0.1))) + (16384 * round((value(v("/Cout" ?result "tran") 3.6e-08) + 0.1))) + (16384 * round((value(v("/Cout" ?result "tran") 3.6e-08) + 0.1)))) - ((1 * round((value(v("/A<0>" ?result "tran") 3.6e-08) + 0.1))) + (2 * round((value(v("/A<1>" ?result "tran") 3.6e-08) + 0.1))) + (4 * round((value(v("/A<2>" ?result "tran") 3.6e-08) + 0.1))) + (8 * round((value(v("/A<3>" ?result "tran") 3.6e-08) + 0.1))) + (16 * round((value(v("/A<4>" ?result "tran") 3.6e-08) + 0.1))) + (32 * round((value(v("/A<5>" ?result "tran") 3.6e-08) + 0.1))) + (64 * round((value(v("/A<6>" ?result "tran") 3.6e-08) + 0.1))) + (128 * round((value(v("/A<7>" ?result "tran") 3.6e-08) + 0.1))) + (256 * round((value(v("/A<8>" ?result "tran") 3.6e-08) + 0.1))) + (512 * round((value(v("/A<9>" ?result "tran") 3.6e-08) + 0.1))) + (1024 * round((value(v("/A<10>" ?result "tran") 3.6e-08) + 0.1))) + (2048 * round((value(v("/A<11>" ?result "tran") 3.6e-08) + 0.1))) + (4096 * round((value(v("/A<12>" ?result "tran") 3.6e-08) + 0.1))) + (8192 * round((value(v("/A<13>" ?result "tran") 3.6e-08) + 0.1))) + (16384 * round((value(v("/A<14>" ?result "tran") 3.6e-08) + 0.1))) + (16384 * round((value(v("/A<15>" ?result "tran") 3.6e-08) + 0.1))) + (16384 * round((value(v("/A<15>" ?result "tran") 3.6e-08) + 0.1))) + (1 * round((value(v("/B<0>" ?result "tran") 3.6e-08) + 0.1))) + (2 * round((value(v("/B<1>" ?result "tran") 3.6e-08) + 0.1))) + (4 * round((value(v("/B<2>" ?result "tran") 3.6e-08) + 0.1))) + (8 * round((value(v("/B<3>" ?result "tran") 3.6e-08) + 0.1))) + (16 * round((value(v("/B<4>" ?result "tran") 3.6e-08) + 0.1))) + (32 * round((value(v("/B<5>" ?result "tran") 3.6e-08) + 0.1))) + (64 * round((value(v("/B<6>" ?result "tran") 3.6e-08) + 0.1))) + (128 * round((value(v("/B<7>" ?result "tran") 3.6e-08) + 0.1))) + (256 * round((value(v("/B<8>" ?result "tran") 3.6e-08) + 0.1))) + (512 * round((value(v("/B<9>" ?result "tran") 3.6e-08) + 0.1))) + (1024 * round((value(v("/B<10>" ?result "tran") 3.6e-08) + 0.1))) + (2048 * round((value(v("/B<11>" ?result "tran") 3.6e-08) + 0.1))) + (4096 * round((value(v("/B<12>" ?result "tran") 3.6e-08) + 0.1))) + (8192 * round((value(v("/B<13>" ?result "tran") 3.6e-08) + 0.1))) + (16384 * round((value(v("/B<14>" ?result "tran") 3.6e-08) + 0.1))) + (16384 * round((value(v("/B<15>" ?result "tran") 3.6e-08) + 0.1))) + (16384 * round((value(v("/B<15>" ?result "tran") 3.6e-08) + 0.1))) + round((value(v("/Cin" ?result "tran") 3.6e-08) + 0.1))))
  Output E23 = (((1 * round((value(v("/S<0>" ?result "tran") 3.8e-08) + 0.1))) + (2 * round((value(v("/S<1>" ?result "tran") 3.8e-08) + 0.1))) + (4 * round((value(v("/S<2>" ?result "tran") 3.8e-08) + 0.1))) + (8 * round((value(v("/S<3>" ?result "tran") 3.8e-08) + 0.1))) + (16 * round((value(v("/S<4>" ?result "tran") 3.8e-08) + 0.1))) + (32 * round((value(v("/S<5>" ?result "tran") 3.8e-08) + 0.1))) + (64 * round((value(v("/S<6>" ?result "tran") 3.8e-08) + 0.1))) + (128 * round((value(v("/S<7>" ?result "tran") 3.8e-08) + 0.1))) + (256 * round((value(v("/S<8>" ?result "tran") 3.8e-08) + 0.1))) + (512 * round((value(v("/S<9>" ?result "tran") 3.8e-08) + 0.1))) + (1024 * round((value(v("/S<10>" ?result "tran") 3.8e-08) + 0.1))) + (2048 * round((value(v("/S<11>" ?result "tran") 3.8e-08) + 0.1))) + (4096 * round((value(v("/S<12>" ?result "tran") 3.8e-08) + 0.1))) + (8192 * round((value(v("/S<13>" ?result "tran") 3.8e-08) + 0.1))) + (16384 * round((value(v("/S<14>" ?result "tran") 3.8e-08) + 0.1))) + (16384 * round((value(v("/S<15>" ?result "tran") 3.8e-08) + 0.1))) + (16384 * round((value(v("/S<15>" ?result "tran") 3.8e-08) + 0.1))) + (16384 * round((value(v("/Cout" ?result "tran") 3.8e-08) + 0.1))) + (16384 * round((value(v("/Cout" ?result "tran") 3.8e-08) + 0.1))) + (16384 * round((value(v("/Cout" ?result "tran") 3.8e-08) + 0.1))) + (16384 * round((value(v("/Cout" ?result "tran") 3.8e-08) + 0.1)))) - ((1 * round((value(v("/A<0>" ?result "tran") 3.8e-08) + 0.1))) + (2 * round((value(v("/A<1>" ?result "tran") 3.8e-08) + 0.1))) + (4 * round((value(v("/A<2>" ?result "tran") 3.8e-08) + 0.1))) + (8 * round((value(v("/A<3>" ?result "tran") 3.8e-08) + 0.1))) + (16 * round((value(v("/A<4>" ?result "tran") 3.8e-08) + 0.1))) + (32 * round((value(v("/A<5>" ?result "tran") 3.8e-08) + 0.1))) + (64 * round((value(v("/A<6>" ?result "tran") 3.8e-08) + 0.1))) + (128 * round((value(v("/A<7>" ?result "tran") 3.8e-08) + 0.1))) + (256 * round((value(v("/A<8>" ?result "tran") 3.8e-08) + 0.1))) + (512 * round((value(v("/A<9>" ?result "tran") 3.8e-08) + 0.1))) + (1024 * round((value(v("/A<10>" ?result "tran") 3.8e-08) + 0.1))) + (2048 * round((value(v("/A<11>" ?result "tran") 3.8e-08) + 0.1))) + (4096 * round((value(v("/A<12>" ?result "tran") 3.8e-08) + 0.1))) + (8192 * round((value(v("/A<13>" ?result "tran") 3.8e-08) + 0.1))) + (16384 * round((value(v("/A<14>" ?result "tran") 3.8e-08) + 0.1))) + (16384 * round((value(v("/A<15>" ?result "tran") 3.8e-08) + 0.1))) + (16384 * round((value(v("/A<15>" ?result "tran") 3.8e-08) + 0.1))) + (1 * round((value(v("/B<0>" ?result "tran") 3.8e-08) + 0.1))) + (2 * round((value(v("/B<1>" ?result "tran") 3.8e-08) + 0.1))) + (4 * round((value(v("/B<2>" ?result "tran") 3.8e-08) + 0.1))) + (8 * round((value(v("/B<3>" ?result "tran") 3.8e-08) + 0.1))) + (16 * round((value(v("/B<4>" ?result "tran") 3.8e-08) + 0.1))) + (32 * round((value(v("/B<5>" ?result "tran") 3.8e-08) + 0.1))) + (64 * round((value(v("/B<6>" ?result "tran") 3.8e-08) + 0.1))) + (128 * round((value(v("/B<7>" ?result "tran") 3.8e-08) + 0.1))) + (256 * round((value(v("/B<8>" ?result "tran") 3.8e-08) + 0.1))) + (512 * round((value(v("/B<9>" ?result "tran") 3.8e-08) + 0.1))) + (1024 * round((value(v("/B<10>" ?result "tran") 3.8e-08) + 0.1))) + (2048 * round((value(v("/B<11>" ?result "tran") 3.8e-08) + 0.1))) + (4096 * round((value(v("/B<12>" ?result "tran") 3.8e-08) + 0.1))) + (8192 * round((value(v("/B<13>" ?result "tran") 3.8e-08) + 0.1))) + (16384 * round((value(v("/B<14>" ?result "tran") 3.8e-08) + 0.1))) + (16384 * round((value(v("/B<15>" ?result "tran") 3.8e-08) + 0.1))) + (16384 * round((value(v("/B<15>" ?result "tran") 3.8e-08) + 0.1))) + round((value(v("/Cin" ?result "tran") 3.8e-08) + 0.1))))
  Output E24 = (((1 * round((value(v("/S<0>" ?result "tran") 4e-08) + 0.1))) + (2 * round((value(v("/S<1>" ?result "tran") 4e-08) + 0.1))) + (4 * round((value(v("/S<2>" ?result "tran") 4e-08) + 0.1))) + (8 * round((value(v("/S<3>" ?result "tran") 4e-08) + 0.1))) + (16 * round((value(v("/S<4>" ?result "tran") 4e-08) + 0.1))) + (32 * round((value(v("/S<5>" ?result "tran") 4e-08) + 0.1))) + (64 * round((value(v("/S<6>" ?result "tran") 4e-08) + 0.1))) + (128 * round((value(v("/S<7>" ?result "tran") 4e-08) + 0.1))) + (256 * round((value(v("/S<8>" ?result "tran") 4e-08) + 0.1))) + (512 * round((value(v("/S<9>" ?result "tran") 4e-08) + 0.1))) + (1024 * round((value(v("/S<10>" ?result "tran") 4e-08) + 0.1))) + (2048 * round((value(v("/S<11>" ?result "tran") 4e-08) + 0.1))) + (4096 * round((value(v("/S<12>" ?result "tran") 4e-08) + 0.1))) + (8192 * round((value(v("/S<13>" ?result "tran") 4e-08) + 0.1))) + (16384 * round((value(v("/S<14>" ?result "tran") 4e-08) + 0.1))) + (16384 * round((value(v("/S<15>" ?result "tran") 4e-08) + 0.1))) + (16384 * round((value(v("/S<15>" ?result "tran") 4e-08) + 0.1))) + (16384 * round((value(v("/Cout" ?result "tran") 4e-08) + 0.1))) + (16384 * round((value(v("/Cout" ?result "tran") 4e-08) + 0.1))) + (16384 * round((value(v("/Cout" ?result "tran") 4e-08) + 0.1))) + (16384 * round((value(v("/Cout" ?result "tran") 4e-08) + 0.1)))) - ((1 * round((value(v("/A<0>" ?result "tran") 4e-08) + 0.1))) + (2 * round((value(v("/A<1>" ?result "tran") 4e-08) + 0.1))) + (4 * round((value(v("/A<2>" ?result "tran") 4e-08) + 0.1))) + (8 * round((value(v("/A<3>" ?result "tran") 4e-08) + 0.1))) + (16 * round((value(v("/A<4>" ?result "tran") 4e-08) + 0.1))) + (32 * round((value(v("/A<5>" ?result "tran") 4e-08) + 0.1))) + (64 * round((value(v("/A<6>" ?result "tran") 4e-08) + 0.1))) + (128 * round((value(v("/A<7>" ?result "tran") 4e-08) + 0.1))) + (256 * round((value(v("/A<8>" ?result "tran") 4e-08) + 0.1))) + (512 * round((value(v("/A<9>" ?result "tran") 4e-08) + 0.1))) + (1024 * round((value(v("/A<10>" ?result "tran") 4e-08) + 0.1))) + (2048 * round((value(v("/A<11>" ?result "tran") 4e-08) + 0.1))) + (4096 * round((value(v("/A<12>" ?result "tran") 4e-08) + 0.1))) + (8192 * round((value(v("/A<13>" ?result "tran") 4e-08) + 0.1))) + (16384 * round((value(v("/A<14>" ?result "tran") 4e-08) + 0.1))) + (16384 * round((value(v("/A<15>" ?result "tran") 4e-08) + 0.1))) + (16384 * round((value(v("/A<15>" ?result "tran") 4e-08) + 0.1))) + (1 * round((value(v("/B<0>" ?result "tran") 4e-08) + 0.1))) + (2 * round((value(v("/B<1>" ?result "tran") 4e-08) + 0.1))) + (4 * round((value(v("/B<2>" ?result "tran") 4e-08) + 0.1))) + (8 * round((value(v("/B<3>" ?result "tran") 4e-08) + 0.1))) + (16 * round((value(v("/B<4>" ?result "tran") 4e-08) + 0.1))) + (32 * round((value(v("/B<5>" ?result "tran") 4e-08) + 0.1))) + (64 * round((value(v("/B<6>" ?result "tran") 4e-08) + 0.1))) + (128 * round((value(v("/B<7>" ?result "tran") 4e-08) + 0.1))) + (256 * round((value(v("/B<8>" ?result "tran") 4e-08) + 0.1))) + (512 * round((value(v("/B<9>" ?result "tran") 4e-08) + 0.1))) + (1024 * round((value(v("/B<10>" ?result "tran") 4e-08) + 0.1))) + (2048 * round((value(v("/B<11>" ?result "tran") 4e-08) + 0.1))) + (4096 * round((value(v("/B<12>" ?result "tran") 4e-08) + 0.1))) + (8192 * round((value(v("/B<13>" ?result "tran") 4e-08) + 0.1))) + (16384 * round((value(v("/B<14>" ?result "tran") 4e-08) + 0.1))) + (16384 * round((value(v("/B<15>" ?result "tran") 4e-08) + 0.1))) + (16384 * round((value(v("/B<15>" ?result "tran") 4e-08) + 0.1))) + round((value(v("/Cin" ?result "tran") 4e-08) + 0.1))))
  Output E25 = (((1 * round((value(v("/S<0>" ?result "tran") 4.2e-08) + 0.1))) + (2 * round((value(v("/S<1>" ?result "tran") 4.2e-08) + 0.1))) + (4 * round((value(v("/S<2>" ?result "tran") 4.2e-08) + 0.1))) + (8 * round((value(v("/S<3>" ?result "tran") 4.2e-08) + 0.1))) + (16 * round((value(v("/S<4>" ?result "tran") 4.2e-08) + 0.1))) + (32 * round((value(v("/S<5>" ?result "tran") 4.2e-08) + 0.1))) + (64 * round((value(v("/S<6>" ?result "tran") 4.2e-08) + 0.1))) + (128 * round((value(v("/S<7>" ?result "tran") 4.2e-08) + 0.1))) + (256 * round((value(v("/S<8>" ?result "tran") 4.2e-08) + 0.1))) + (512 * round((value(v("/S<9>" ?result "tran") 4.2e-08) + 0.1))) + (1024 * round((value(v("/S<10>" ?result "tran") 4.2e-08) + 0.1))) + (2048 * round((value(v("/S<11>" ?result "tran") 4.2e-08) + 0.1))) + (4096 * round((value(v("/S<12>" ?result "tran") 4.2e-08) + 0.1))) + (8192 * round((value(v("/S<13>" ?result "tran") 4.2e-08) + 0.1))) + (16384 * round((value(v("/S<14>" ?result "tran") 4.2e-08) + 0.1))) + (16384 * round((value(v("/S<15>" ?result "tran") 4.2e-08) + 0.1))) + (16384 * round((value(v("/S<15>" ?result "tran") 4.2e-08) + 0.1))) + (16384 * round((value(v("/Cout" ?result "tran") 4.2e-08) + 0.1))) + (16384 * round((value(v("/Cout" ?result "tran") 4.2e-08) + 0.1))) + (16384 * round((value(v("/Cout" ?result "tran") 4.2e-08) + 0.1))) + (16384 * round((value(v("/Cout" ?result "tran") 4.2e-08) + 0.1)))) - ((1 * round((value(v("/A<0>" ?result "tran") 4.2e-08) + 0.1))) + (2 * round((value(v("/A<1>" ?result "tran") 4.2e-08) + 0.1))) + (4 * round((value(v("/A<2>" ?result "tran") 4.2e-08) + 0.1))) + (8 * round((value(v("/A<3>" ?result "tran") 4.2e-08) + 0.1))) + (16 * round((value(v("/A<4>" ?result "tran") 4.2e-08) + 0.1))) + (32 * round((value(v("/A<5>" ?result "tran") 4.2e-08) + 0.1))) + (64 * round((value(v("/A<6>" ?result "tran") 4.2e-08) + 0.1))) + (128 * round((value(v("/A<7>" ?result "tran") 4.2e-08) + 0.1))) + (256 * round((value(v("/A<8>" ?result "tran") 4.2e-08) + 0.1))) + (512 * round((value(v("/A<9>" ?result "tran") 4.2e-08) + 0.1))) + (1024 * round((value(v("/A<10>" ?result "tran") 4.2e-08) + 0.1))) + (2048 * round((value(v("/A<11>" ?result "tran") 4.2e-08) + 0.1))) + (4096 * round((value(v("/A<12>" ?result "tran") 4.2e-08) + 0.1))) + (8192 * round((value(v("/A<13>" ?result "tran") 4.2e-08) + 0.1))) + (16384 * round((value(v("/A<14>" ?result "tran") 4.2e-08) + 0.1))) + (16384 * round((value(v("/A<15>" ?result "tran") 4.2e-08) + 0.1))) + (16384 * round((value(v("/A<15>" ?result "tran") 4.2e-08) + 0.1))) + (1 * round((value(v("/B<0>" ?result "tran") 4.2e-08) + 0.1))) + (2 * round((value(v("/B<1>" ?result "tran") 4.2e-08) + 0.1))) + (4 * round((value(v("/B<2>" ?result "tran") 4.2e-08) + 0.1))) + (8 * round((value(v("/B<3>" ?result "tran") 4.2e-08) + 0.1))) + (16 * round((value(v("/B<4>" ?result "tran") 4.2e-08) + 0.1))) + (32 * round((value(v("/B<5>" ?result "tran") 4.2e-08) + 0.1))) + (64 * round((value(v("/B<6>" ?result "tran") 4.2e-08) + 0.1))) + (128 * round((value(v("/B<7>" ?result "tran") 4.2e-08) + 0.1))) + (256 * round((value(v("/B<8>" ?result "tran") 4.2e-08) + 0.1))) + (512 * round((value(v("/B<9>" ?result "tran") 4.2e-08) + 0.1))) + (1024 * round((value(v("/B<10>" ?result "tran") 4.2e-08) + 0.1))) + (2048 * round((value(v("/B<11>" ?result "tran") 4.2e-08) + 0.1))) + (4096 * round((value(v("/B<12>" ?result "tran") 4.2e-08) + 0.1))) + (8192 * round((value(v("/B<13>" ?result "tran") 4.2e-08) + 0.1))) + (16384 * round((value(v("/B<14>" ?result "tran") 4.2e-08) + 0.1))) + (16384 * round((value(v("/B<15>" ?result "tran") 4.2e-08) + 0.1))) + (16384 * round((value(v("/B<15>" ?result "tran") 4.2e-08) + 0.1))) + round((value(v("/Cin" ?result "tran") 4.2e-08) + 0.1))))
  Output E26 = (((1 * round((value(v("/S<0>" ?result "tran") 4.4e-08) + 0.1))) + (2 * round((value(v("/S<1>" ?result "tran") 4.4e-08) + 0.1))) + (4 * round((value(v("/S<2>" ?result "tran") 4.4e-08) + 0.1))) + (8 * round((value(v("/S<3>" ?result "tran") 4.4e-08) + 0.1))) + (16 * round((value(v("/S<4>" ?result "tran") 4.4e-08) + 0.1))) + (32 * round((value(v("/S<5>" ?result "tran") 4.4e-08) + 0.1))) + (64 * round((value(v("/S<6>" ?result "tran") 4.4e-08) + 0.1))) + (128 * round((value(v("/S<7>" ?result "tran") 4.4e-08) + 0.1))) + (256 * round((value(v("/S<8>" ?result "tran") 4.4e-08) + 0.1))) + (512 * round((value(v("/S<9>" ?result "tran") 4.4e-08) + 0.1))) + (1024 * round((value(v("/S<10>" ?result "tran") 4.4e-08) + 0.1))) + (2048 * round((value(v("/S<11>" ?result "tran") 4.4e-08) + 0.1))) + (4096 * round((value(v("/S<12>" ?result "tran") 4.4e-08) + 0.1))) + (8192 * round((value(v("/S<13>" ?result "tran") 4.4e-08) + 0.1))) + (16384 * round((value(v("/S<14>" ?result "tran") 4.4e-08) + 0.1))) + (16384 * round((value(v("/S<15>" ?result "tran") 4.4e-08) + 0.1))) + (16384 * round((value(v("/S<15>" ?result "tran") 4.4e-08) + 0.1))) + (16384 * round((value(v("/Cout" ?result "tran") 4.4e-08) + 0.1))) + (16384 * round((value(v("/Cout" ?result "tran") 4.4e-08) + 0.1))) + (16384 * round((value(v("/Cout" ?result "tran") 4.4e-08) + 0.1))) + (16384 * round((value(v("/Cout" ?result "tran") 4.4e-08) + 0.1)))) - ((1 * round((value(v("/A<0>" ?result "tran") 4.4e-08) + 0.1))) + (2 * round((value(v("/A<1>" ?result "tran") 4.4e-08) + 0.1))) + (4 * round((value(v("/A<2>" ?result "tran") 4.4e-08) + 0.1))) + (8 * round((value(v("/A<3>" ?result "tran") 4.4e-08) + 0.1))) + (16 * round((value(v("/A<4>" ?result "tran") 4.4e-08) + 0.1))) + (32 * round((value(v("/A<5>" ?result "tran") 4.4e-08) + 0.1))) + (64 * round((value(v("/A<6>" ?result "tran") 4.4e-08) + 0.1))) + (128 * round((value(v("/A<7>" ?result "tran") 4.4e-08) + 0.1))) + (256 * round((value(v("/A<8>" ?result "tran") 4.4e-08) + 0.1))) + (512 * round((value(v("/A<9>" ?result "tran") 4.4e-08) + 0.1))) + (1024 * round((value(v("/A<10>" ?result "tran") 4.4e-08) + 0.1))) + (2048 * round((value(v("/A<11>" ?result "tran") 4.4e-08) + 0.1))) + (4096 * round((value(v("/A<12>" ?result "tran") 4.4e-08) + 0.1))) + (8192 * round((value(v("/A<13>" ?result "tran") 4.4e-08) + 0.1))) + (16384 * round((value(v("/A<14>" ?result "tran") 4.4e-08) + 0.1))) + (16384 * round((value(v("/A<15>" ?result "tran") 4.4e-08) + 0.1))) + (16384 * round((value(v("/A<15>" ?result "tran") 4.4e-08) + 0.1))) + (1 * round((value(v("/B<0>" ?result "tran") 4.4e-08) + 0.1))) + (2 * round((value(v("/B<1>" ?result "tran") 4.4e-08) + 0.1))) + (4 * round((value(v("/B<2>" ?result "tran") 4.4e-08) + 0.1))) + (8 * round((value(v("/B<3>" ?result "tran") 4.4e-08) + 0.1))) + (16 * round((value(v("/B<4>" ?result "tran") 4.4e-08) + 0.1))) + (32 * round((value(v("/B<5>" ?result "tran") 4.4e-08) + 0.1))) + (64 * round((value(v("/B<6>" ?result "tran") 4.4e-08) + 0.1))) + (128 * round((value(v("/B<7>" ?result "tran") 4.4e-08) + 0.1))) + (256 * round((value(v("/B<8>" ?result "tran") 4.4e-08) + 0.1))) + (512 * round((value(v("/B<9>" ?result "tran") 4.4e-08) + 0.1))) + (1024 * round((value(v("/B<10>" ?result "tran") 4.4e-08) + 0.1))) + (2048 * round((value(v("/B<11>" ?result "tran") 4.4e-08) + 0.1))) + (4096 * round((value(v("/B<12>" ?result "tran") 4.4e-08) + 0.1))) + (8192 * round((value(v("/B<13>" ?result "tran") 4.4e-08) + 0.1))) + (16384 * round((value(v("/B<14>" ?result "tran") 4.4e-08) + 0.1))) + (16384 * round((value(v("/B<15>" ?result "tran") 4.4e-08) + 0.1))) + (16384 * round((value(v("/B<15>" ?result "tran") 4.4e-08) + 0.1))) + round((value(v("/Cin" ?result "tran") 4.4e-08) + 0.1))))
  Output E27 = (((1 * round((value(v("/S<0>" ?result "tran") 4.6e-08) + 0.1))) + (2 * round((value(v("/S<1>" ?result "tran") 4.6e-08) + 0.1))) + (4 * round((value(v("/S<2>" ?result "tran") 4.6e-08) + 0.1))) + (8 * round((value(v("/S<3>" ?result "tran") 4.6e-08) + 0.1))) + (16 * round((value(v("/S<4>" ?result "tran") 4.6e-08) + 0.1))) + (32 * round((value(v("/S<5>" ?result "tran") 4.6e-08) + 0.1))) + (64 * round((value(v("/S<6>" ?result "tran") 4.6e-08) + 0.1))) + (128 * round((value(v("/S<7>" ?result "tran") 4.6e-08) + 0.1))) + (256 * round((value(v("/S<8>" ?result "tran") 4.6e-08) + 0.1))) + (512 * round((value(v("/S<9>" ?result "tran") 4.6e-08) + 0.1))) + (1024 * round((value(v("/S<10>" ?result "tran") 4.6e-08) + 0.1))) + (2048 * round((value(v("/S<11>" ?result "tran") 4.6e-08) + 0.1))) + (4096 * round((value(v("/S<12>" ?result "tran") 4.6e-08) + 0.1))) + (8192 * round((value(v("/S<13>" ?result "tran") 4.6e-08) + 0.1))) + (16384 * round((value(v("/S<14>" ?result "tran") 4.6e-08) + 0.1))) + (16384 * round((value(v("/S<15>" ?result "tran") 4.6e-08) + 0.1))) + (16384 * round((value(v("/S<15>" ?result "tran") 4.6e-08) + 0.1))) + (16384 * round((value(v("/Cout" ?result "tran") 4.6e-08) + 0.1))) + (16384 * round((value(v("/Cout" ?result "tran") 4.6e-08) + 0.1))) + (16384 * round((value(v("/Cout" ?result "tran") 4.6e-08) + 0.1))) + (16384 * round((value(v("/Cout" ?result "tran") 4.6e-08) + 0.1)))) - ((1 * round((value(v("/A<0>" ?result "tran") 4.6e-08) + 0.1))) + (2 * round((value(v("/A<1>" ?result "tran") 4.6e-08) + 0.1))) + (4 * round((value(v("/A<2>" ?result "tran") 4.6e-08) + 0.1))) + (8 * round((value(v("/A<3>" ?result "tran") 4.6e-08) + 0.1))) + (16 * round((value(v("/A<4>" ?result "tran") 4.6e-08) + 0.1))) + (32 * round((value(v("/A<5>" ?result "tran") 4.6e-08) + 0.1))) + (64 * round((value(v("/A<6>" ?result "tran") 4.6e-08) + 0.1))) + (128 * round((value(v("/A<7>" ?result "tran") 4.6e-08) + 0.1))) + (256 * round((value(v("/A<8>" ?result "tran") 4.6e-08) + 0.1))) + (512 * round((value(v("/A<9>" ?result "tran") 4.6e-08) + 0.1))) + (1024 * round((value(v("/A<10>" ?result "tran") 4.6e-08) + 0.1))) + (2048 * round((value(v("/A<11>" ?result "tran") 4.6e-08) + 0.1))) + (4096 * round((value(v("/A<12>" ?result "tran") 4.6e-08) + 0.1))) + (8192 * round((value(v("/A<13>" ?result "tran") 4.6e-08) + 0.1))) + (16384 * round((value(v("/A<14>" ?result "tran") 4.6e-08) + 0.1))) + (16384 * round((value(v("/A<15>" ?result "tran") 4.6e-08) + 0.1))) + (16384 * round((value(v("/A<15>" ?result "tran") 4.6e-08) + 0.1))) + (1 * round((value(v("/B<0>" ?result "tran") 4.6e-08) + 0.1))) + (2 * round((value(v("/B<1>" ?result "tran") 4.6e-08) + 0.1))) + (4 * round((value(v("/B<2>" ?result "tran") 4.6e-08) + 0.1))) + (8 * round((value(v("/B<3>" ?result "tran") 4.6e-08) + 0.1))) + (16 * round((value(v("/B<4>" ?result "tran") 4.6e-08) + 0.1))) + (32 * round((value(v("/B<5>" ?result "tran") 4.6e-08) + 0.1))) + (64 * round((value(v("/B<6>" ?result "tran") 4.6e-08) + 0.1))) + (128 * round((value(v("/B<7>" ?result "tran") 4.6e-08) + 0.1))) + (256 * round((value(v("/B<8>" ?result "tran") 4.6e-08) + 0.1))) + (512 * round((value(v("/B<9>" ?result "tran") 4.6e-08) + 0.1))) + (1024 * round((value(v("/B<10>" ?result "tran") 4.6e-08) + 0.1))) + (2048 * round((value(v("/B<11>" ?result "tran") 4.6e-08) + 0.1))) + (4096 * round((value(v("/B<12>" ?result "tran") 4.6e-08) + 0.1))) + (8192 * round((value(v("/B<13>" ?result "tran") 4.6e-08) + 0.1))) + (16384 * round((value(v("/B<14>" ?result "tran") 4.6e-08) + 0.1))) + (16384 * round((value(v("/B<15>" ?result "tran") 4.6e-08) + 0.1))) + (16384 * round((value(v("/B<15>" ?result "tran") 4.6e-08) + 0.1))) + round((value(v("/Cin" ?result "tran") 4.6e-08) + 0.1))))
  Output E28 = (((1 * round((value(v("/S<0>" ?result "tran") 4.8e-08) + 0.1))) + (2 * round((value(v("/S<1>" ?result "tran") 4.8e-08) + 0.1))) + (4 * round((value(v("/S<2>" ?result "tran") 4.8e-08) + 0.1))) + (8 * round((value(v("/S<3>" ?result "tran") 4.8e-08) + 0.1))) + (16 * round((value(v("/S<4>" ?result "tran") 4.8e-08) + 0.1))) + (32 * round((value(v("/S<5>" ?result "tran") 4.8e-08) + 0.1))) + (64 * round((value(v("/S<6>" ?result "tran") 4.8e-08) + 0.1))) + (128 * round((value(v("/S<7>" ?result "tran") 4.8e-08) + 0.1))) + (256 * round((value(v("/S<8>" ?result "tran") 4.8e-08) + 0.1))) + (512 * round((value(v("/S<9>" ?result "tran") 4.8e-08) + 0.1))) + (1024 * round((value(v("/S<10>" ?result "tran") 4.8e-08) + 0.1))) + (2048 * round((value(v("/S<11>" ?result "tran") 4.8e-08) + 0.1))) + (4096 * round((value(v("/S<12>" ?result "tran") 4.8e-08) + 0.1))) + (8192 * round((value(v("/S<13>" ?result "tran") 4.8e-08) + 0.1))) + (16384 * round((value(v("/S<14>" ?result "tran") 4.8e-08) + 0.1))) + (16384 * round((value(v("/S<15>" ?result "tran") 4.8e-08) + 0.1))) + (16384 * round((value(v("/S<15>" ?result "tran") 4.8e-08) + 0.1))) + (16384 * round((value(v("/Cout" ?result "tran") 4.8e-08) + 0.1))) + (16384 * round((value(v("/Cout" ?result "tran") 4.8e-08) + 0.1))) + (16384 * round((value(v("/Cout" ?result "tran") 4.8e-08) + 0.1))) + (16384 * round((value(v("/Cout" ?result "tran") 4.8e-08) + 0.1)))) - ((1 * round((value(v("/A<0>" ?result "tran") 4.8e-08) + 0.1))) + (2 * round((value(v("/A<1>" ?result "tran") 4.8e-08) + 0.1))) + (4 * round((value(v("/A<2>" ?result "tran") 4.8e-08) + 0.1))) + (8 * round((value(v("/A<3>" ?result "tran") 4.8e-08) + 0.1))) + (16 * round((value(v("/A<4>" ?result "tran") 4.8e-08) + 0.1))) + (32 * round((value(v("/A<5>" ?result "tran") 4.8e-08) + 0.1))) + (64 * round((value(v("/A<6>" ?result "tran") 4.8e-08) + 0.1))) + (128 * round((value(v("/A<7>" ?result "tran") 4.8e-08) + 0.1))) + (256 * round((value(v("/A<8>" ?result "tran") 4.8e-08) + 0.1))) + (512 * round((value(v("/A<9>" ?result "tran") 4.8e-08) + 0.1))) + (1024 * round((value(v("/A<10>" ?result "tran") 4.8e-08) + 0.1))) + (2048 * round((value(v("/A<11>" ?result "tran") 4.8e-08) + 0.1))) + (4096 * round((value(v("/A<12>" ?result "tran") 4.8e-08) + 0.1))) + (8192 * round((value(v("/A<13>" ?result "tran") 4.8e-08) + 0.1))) + (16384 * round((value(v("/A<14>" ?result "tran") 4.8e-08) + 0.1))) + (16384 * round((value(v("/A<15>" ?result "tran") 4.8e-08) + 0.1))) + (16384 * round((value(v("/A<15>" ?result "tran") 4.8e-08) + 0.1))) + (1 * round((value(v("/B<0>" ?result "tran") 4.8e-08) + 0.1))) + (2 * round((value(v("/B<1>" ?result "tran") 4.8e-08) + 0.1))) + (4 * round((value(v("/B<2>" ?result "tran") 4.8e-08) + 0.1))) + (8 * round((value(v("/B<3>" ?result "tran") 4.8e-08) + 0.1))) + (16 * round((value(v("/B<4>" ?result "tran") 4.8e-08) + 0.1))) + (32 * round((value(v("/B<5>" ?result "tran") 4.8e-08) + 0.1))) + (64 * round((value(v("/B<6>" ?result "tran") 4.8e-08) + 0.1))) + (128 * round((value(v("/B<7>" ?result "tran") 4.8e-08) + 0.1))) + (256 * round((value(v("/B<8>" ?result "tran") 4.8e-08) + 0.1))) + (512 * round((value(v("/B<9>" ?result "tran") 4.8e-08) + 0.1))) + (1024 * round((value(v("/B<10>" ?result "tran") 4.8e-08) + 0.1))) + (2048 * round((value(v("/B<11>" ?result "tran") 4.8e-08) + 0.1))) + (4096 * round((value(v("/B<12>" ?result "tran") 4.8e-08) + 0.1))) + (8192 * round((value(v("/B<13>" ?result "tran") 4.8e-08) + 0.1))) + (16384 * round((value(v("/B<14>" ?result "tran") 4.8e-08) + 0.1))) + (16384 * round((value(v("/B<15>" ?result "tran") 4.8e-08) + 0.1))) + (16384 * round((value(v("/B<15>" ?result "tran") 4.8e-08) + 0.1))) + round((value(v("/Cin" ?result "tran") 4.8e-08) + 0.1))))
  Output E29 = (((1 * round((value(v("/S<0>" ?result "tran") 5e-08) + 0.1))) + (2 * round((value(v("/S<1>" ?result "tran") 5e-08) + 0.1))) + (4 * round((value(v("/S<2>" ?result "tran") 5e-08) + 0.1))) + (8 * round((value(v("/S<3>" ?result "tran") 5e-08) + 0.1))) + (16 * round((value(v("/S<4>" ?result "tran") 5e-08) + 0.1))) + (32 * round((value(v("/S<5>" ?result "tran") 5e-08) + 0.1))) + (64 * round((value(v("/S<6>" ?result "tran") 5e-08) + 0.1))) + (128 * round((value(v("/S<7>" ?result "tran") 5e-08) + 0.1))) + (256 * round((value(v("/S<8>" ?result "tran") 5e-08) + 0.1))) + (512 * round((value(v("/S<9>" ?result "tran") 5e-08) + 0.1))) + (1024 * round((value(v("/S<10>" ?result "tran") 5e-08) + 0.1))) + (2048 * round((value(v("/S<11>" ?result "tran") 5e-08) + 0.1))) + (4096 * round((value(v("/S<12>" ?result "tran") 5e-08) + 0.1))) + (8192 * round((value(v("/S<13>" ?result "tran") 5e-08) + 0.1))) + (16384 * round((value(v("/S<14>" ?result "tran") 5e-08) + 0.1))) + (16384 * round((value(v("/S<15>" ?result "tran") 5e-08) + 0.1))) + (16384 * round((value(v("/S<15>" ?result "tran") 5e-08) + 0.1))) + (16384 * round((value(v("/Cout" ?result "tran") 5e-08) + 0.1))) + (16384 * round((value(v("/Cout" ?result "tran") 5e-08) + 0.1))) + (16384 * round((value(v("/Cout" ?result "tran") 5e-08) + 0.1))) + (16384 * round((value(v("/Cout" ?result "tran") 5e-08) + 0.1)))) - ((1 * round((value(v("/A<0>" ?result "tran") 5e-08) + 0.1))) + (2 * round((value(v("/A<1>" ?result "tran") 5e-08) + 0.1))) + (4 * round((value(v("/A<2>" ?result "tran") 5e-08) + 0.1))) + (8 * round((value(v("/A<3>" ?result "tran") 5e-08) + 0.1))) + (16 * round((value(v("/A<4>" ?result "tran") 5e-08) + 0.1))) + (32 * round((value(v("/A<5>" ?result "tran") 5e-08) + 0.1))) + (64 * round((value(v("/A<6>" ?result "tran") 5e-08) + 0.1))) + (128 * round((value(v("/A<7>" ?result "tran") 5e-08) + 0.1))) + (256 * round((value(v("/A<8>" ?result "tran") 5e-08) + 0.1))) + (512 * round((value(v("/A<9>" ?result "tran") 5e-08) + 0.1))) + (1024 * round((value(v("/A<10>" ?result "tran") 5e-08) + 0.1))) + (2048 * round((value(v("/A<11>" ?result "tran") 5e-08) + 0.1))) + (4096 * round((value(v("/A<12>" ?result "tran") 5e-08) + 0.1))) + (8192 * round((value(v("/A<13>" ?result "tran") 5e-08) + 0.1))) + (16384 * round((value(v("/A<14>" ?result "tran") 5e-08) + 0.1))) + (16384 * round((value(v("/A<15>" ?result "tran") 5e-08) + 0.1))) + (16384 * round((value(v("/A<15>" ?result "tran") 5e-08) + 0.1))) + (1 * round((value(v("/B<0>" ?result "tran") 5e-08) + 0.1))) + (2 * round((value(v("/B<1>" ?result "tran") 5e-08) + 0.1))) + (4 * round((value(v("/B<2>" ?result "tran") 5e-08) + 0.1))) + (8 * round((value(v("/B<3>" ?result "tran") 5e-08) + 0.1))) + (16 * round((value(v("/B<4>" ?result "tran") 5e-08) + 0.1))) + (32 * round((value(v("/B<5>" ?result "tran") 5e-08) + 0.1))) + (64 * round((value(v("/B<6>" ?result "tran") 5e-08) + 0.1))) + (128 * round((value(v("/B<7>" ?result "tran") 5e-08) + 0.1))) + (256 * round((value(v("/B<8>" ?result "tran") 5e-08) + 0.1))) + (512 * round((value(v("/B<9>" ?result "tran") 5e-08) + 0.1))) + (1024 * round((value(v("/B<10>" ?result "tran") 5e-08) + 0.1))) + (2048 * round((value(v("/B<11>" ?result "tran") 5e-08) + 0.1))) + (4096 * round((value(v("/B<12>" ?result "tran") 5e-08) + 0.1))) + (8192 * round((value(v("/B<13>" ?result "tran") 5e-08) + 0.1))) + (16384 * round((value(v("/B<14>" ?result "tran") 5e-08) + 0.1))) + (16384 * round((value(v("/B<15>" ?result "tran") 5e-08) + 0.1))) + (16384 * round((value(v("/B<15>" ?result "tran") 5e-08) + 0.1))) + round((value(v("/Cin" ?result "tran") 5e-08) + 0.1))))
  Output E30 = (((1 * round((value(v("/S<0>" ?result "tran") 5.2e-08) + 0.1))) + (2 * round((value(v("/S<1>" ?result "tran") 5.2e-08) + 0.1))) + (4 * round((value(v("/S<2>" ?result "tran") 5.2e-08) + 0.1))) + (8 * round((value(v("/S<3>" ?result "tran") 5.2e-08) + 0.1))) + (16 * round((value(v("/S<4>" ?result "tran") 5.2e-08) + 0.1))) + (32 * round((value(v("/S<5>" ?result "tran") 5.2e-08) + 0.1))) + (64 * round((value(v("/S<6>" ?result "tran") 5.2e-08) + 0.1))) + (128 * round((value(v("/S<7>" ?result "tran") 5.2e-08) + 0.1))) + (256 * round((value(v("/S<8>" ?result "tran") 5.2e-08) + 0.1))) + (512 * round((value(v("/S<9>" ?result "tran") 5.2e-08) + 0.1))) + (1024 * round((value(v("/S<10>" ?result "tran") 5.2e-08) + 0.1))) + (2048 * round((value(v("/S<11>" ?result "tran") 5.2e-08) + 0.1))) + (4096 * round((value(v("/S<12>" ?result "tran") 5.2e-08) + 0.1))) + (8192 * round((value(v("/S<13>" ?result "tran") 5.2e-08) + 0.1))) + (16384 * round((value(v("/S<14>" ?result "tran") 5.2e-08) + 0.1))) + (16384 * round((value(v("/S<15>" ?result "tran") 5.2e-08) + 0.1))) + (16384 * round((value(v("/S<15>" ?result "tran") 5.2e-08) + 0.1))) + (16384 * round((value(v("/Cout" ?result "tran") 5.2e-08) + 0.1))) + (16384 * round((value(v("/Cout" ?result "tran") 5.2e-08) + 0.1))) + (16384 * round((value(v("/Cout" ?result "tran") 5.2e-08) + 0.1))) + (16384 * round((value(v("/Cout" ?result "tran") 5.2e-08) + 0.1)))) - ((1 * round((value(v("/A<0>" ?result "tran") 5.2e-08) + 0.1))) + (2 * round((value(v("/A<1>" ?result "tran") 5.2e-08) + 0.1))) + (4 * round((value(v("/A<2>" ?result "tran") 5.2e-08) + 0.1))) + (8 * round((value(v("/A<3>" ?result "tran") 5.2e-08) + 0.1))) + (16 * round((value(v("/A<4>" ?result "tran") 5.2e-08) + 0.1))) + (32 * round((value(v("/A<5>" ?result "tran") 5.2e-08) + 0.1))) + (64 * round((value(v("/A<6>" ?result "tran") 5.2e-08) + 0.1))) + (128 * round((value(v("/A<7>" ?result "tran") 5.2e-08) + 0.1))) + (256 * round((value(v("/A<8>" ?result "tran") 5.2e-08) + 0.1))) + (512 * round((value(v("/A<9>" ?result "tran") 5.2e-08) + 0.1))) + (1024 * round((value(v("/A<10>" ?result "tran") 5.2e-08) + 0.1))) + (2048 * round((value(v("/A<11>" ?result "tran") 5.2e-08) + 0.1))) + (4096 * round((value(v("/A<12>" ?result "tran") 5.2e-08) + 0.1))) + (8192 * round((value(v("/A<13>" ?result "tran") 5.2e-08) + 0.1))) + (16384 * round((value(v("/A<14>" ?result "tran") 5.2e-08) + 0.1))) + (16384 * round((value(v("/A<15>" ?result "tran") 5.2e-08) + 0.1))) + (16384 * round((value(v("/A<15>" ?result "tran") 5.2e-08) + 0.1))) + (1 * round((value(v("/B<0>" ?result "tran") 5.2e-08) + 0.1))) + (2 * round((value(v("/B<1>" ?result "tran") 5.2e-08) + 0.1))) + (4 * round((value(v("/B<2>" ?result "tran") 5.2e-08) + 0.1))) + (8 * round((value(v("/B<3>" ?result "tran") 5.2e-08) + 0.1))) + (16 * round((value(v("/B<4>" ?result "tran") 5.2e-08) + 0.1))) + (32 * round((value(v("/B<5>" ?result "tran") 5.2e-08) + 0.1))) + (64 * round((value(v("/B<6>" ?result "tran") 5.2e-08) + 0.1))) + (128 * round((value(v("/B<7>" ?result "tran") 5.2e-08) + 0.1))) + (256 * round((value(v("/B<8>" ?result "tran") 5.2e-08) + 0.1))) + (512 * round((value(v("/B<9>" ?result "tran") 5.2e-08) + 0.1))) + (1024 * round((value(v("/B<10>" ?result "tran") 5.2e-08) + 0.1))) + (2048 * round((value(v("/B<11>" ?result "tran") 5.2e-08) + 0.1))) + (4096 * round((value(v("/B<12>" ?result "tran") 5.2e-08) + 0.1))) + (8192 * round((value(v("/B<13>" ?result "tran") 5.2e-08) + 0.1))) + (16384 * round((value(v("/B<14>" ?result "tran") 5.2e-08) + 0.1))) + (16384 * round((value(v("/B<15>" ?result "tran") 5.2e-08) + 0.1))) + (16384 * round((value(v("/B<15>" ?result "tran") 5.2e-08) + 0.1))) + round((value(v("/Cin" ?result "tran") 5.2e-08) + 0.1))))
  Output E31 = (((1 * round((value(v("/S<0>" ?result "tran") 5.4e-08) + 0.1))) + (2 * round((value(v("/S<1>" ?result "tran") 5.4e-08) + 0.1))) + (4 * round((value(v("/S<2>" ?result "tran") 5.4e-08) + 0.1))) + (8 * round((value(v("/S<3>" ?result "tran") 5.4e-08) + 0.1))) + (16 * round((value(v("/S<4>" ?result "tran") 5.4e-08) + 0.1))) + (32 * round((value(v("/S<5>" ?result "tran") 5.4e-08) + 0.1))) + (64 * round((value(v("/S<6>" ?result "tran") 5.4e-08) + 0.1))) + (128 * round((value(v("/S<7>" ?result "tran") 5.4e-08) + 0.1))) + (256 * round((value(v("/S<8>" ?result "tran") 5.4e-08) + 0.1))) + (512 * round((value(v("/S<9>" ?result "tran") 5.4e-08) + 0.1))) + (1024 * round((value(v("/S<10>" ?result "tran") 5.4e-08) + 0.1))) + (2048 * round((value(v("/S<11>" ?result "tran") 5.4e-08) + 0.1))) + (4096 * round((value(v("/S<12>" ?result "tran") 5.4e-08) + 0.1))) + (8192 * round((value(v("/S<13>" ?result "tran") 5.4e-08) + 0.1))) + (16384 * round((value(v("/S<14>" ?result "tran") 5.4e-08) + 0.1))) + (16384 * round((value(v("/S<15>" ?result "tran") 5.4e-08) + 0.1))) + (16384 * round((value(v("/S<15>" ?result "tran") 5.4e-08) + 0.1))) + (16384 * round((value(v("/Cout" ?result "tran") 5.4e-08) + 0.1))) + (16384 * round((value(v("/Cout" ?result "tran") 5.4e-08) + 0.1))) + (16384 * round((value(v("/Cout" ?result "tran") 5.4e-08) + 0.1))) + (16384 * round((value(v("/Cout" ?result "tran") 5.4e-08) + 0.1)))) - ((1 * round((value(v("/A<0>" ?result "tran") 5.4e-08) + 0.1))) + (2 * round((value(v("/A<1>" ?result "tran") 5.4e-08) + 0.1))) + (4 * round((value(v("/A<2>" ?result "tran") 5.4e-08) + 0.1))) + (8 * round((value(v("/A<3>" ?result "tran") 5.4e-08) + 0.1))) + (16 * round((value(v("/A<4>" ?result "tran") 5.4e-08) + 0.1))) + (32 * round((value(v("/A<5>" ?result "tran") 5.4e-08) + 0.1))) + (64 * round((value(v("/A<6>" ?result "tran") 5.4e-08) + 0.1))) + (128 * round((value(v("/A<7>" ?result "tran") 5.4e-08) + 0.1))) + (256 * round((value(v("/A<8>" ?result "tran") 5.4e-08) + 0.1))) + (512 * round((value(v("/A<9>" ?result "tran") 5.4e-08) + 0.1))) + (1024 * round((value(v("/A<10>" ?result "tran") 5.4e-08) + 0.1))) + (2048 * round((value(v("/A<11>" ?result "tran") 5.4e-08) + 0.1))) + (4096 * round((value(v("/A<12>" ?result "tran") 5.4e-08) + 0.1))) + (8192 * round((value(v("/A<13>" ?result "tran") 5.4e-08) + 0.1))) + (16384 * round((value(v("/A<14>" ?result "tran") 5.4e-08) + 0.1))) + (16384 * round((value(v("/A<15>" ?result "tran") 5.4e-08) + 0.1))) + (16384 * round((value(v("/A<15>" ?result "tran") 5.4e-08) + 0.1))) + (1 * round((value(v("/B<0>" ?result "tran") 5.4e-08) + 0.1))) + (2 * round((value(v("/B<1>" ?result "tran") 5.4e-08) + 0.1))) + (4 * round((value(v("/B<2>" ?result "tran") 5.4e-08) + 0.1))) + (8 * round((value(v("/B<3>" ?result "tran") 5.4e-08) + 0.1))) + (16 * round((value(v("/B<4>" ?result "tran") 5.4e-08) + 0.1))) + (32 * round((value(v("/B<5>" ?result "tran") 5.4e-08) + 0.1))) + (64 * round((value(v("/B<6>" ?result "tran") 5.4e-08) + 0.1))) + (128 * round((value(v("/B<7>" ?result "tran") 5.4e-08) + 0.1))) + (256 * round((value(v("/B<8>" ?result "tran") 5.4e-08) + 0.1))) + (512 * round((value(v("/B<9>" ?result "tran") 5.4e-08) + 0.1))) + (1024 * round((value(v("/B<10>" ?result "tran") 5.4e-08) + 0.1))) + (2048 * round((value(v("/B<11>" ?result "tran") 5.4e-08) + 0.1))) + (4096 * round((value(v("/B<12>" ?result "tran") 5.4e-08) + 0.1))) + (8192 * round((value(v("/B<13>" ?result "tran") 5.4e-08) + 0.1))) + (16384 * round((value(v("/B<14>" ?result "tran") 5.4e-08) + 0.1))) + (16384 * round((value(v("/B<15>" ?result "tran") 5.4e-08) + 0.1))) + (16384 * round((value(v("/B<15>" ?result "tran") 5.4e-08) + 0.1))) + round((value(v("/Cin" ?result "tran") 5.4e-08) + 0.1))))
  Output E32 = (((1 * round((value(v("/S<0>" ?result "tran") 5.6e-08) + 0.1))) + (2 * round((value(v("/S<1>" ?result "tran") 5.6e-08) + 0.1))) + (4 * round((value(v("/S<2>" ?result "tran") 5.6e-08) + 0.1))) + (8 * round((value(v("/S<3>" ?result "tran") 5.6e-08) + 0.1))) + (16 * round((value(v("/S<4>" ?result "tran") 5.6e-08) + 0.1))) + (32 * round((value(v("/S<5>" ?result "tran") 5.6e-08) + 0.1))) + (64 * round((value(v("/S<6>" ?result "tran") 5.6e-08) + 0.1))) + (128 * round((value(v("/S<7>" ?result "tran") 5.6e-08) + 0.1))) + (256 * round((value(v("/S<8>" ?result "tran") 5.6e-08) + 0.1))) + (512 * round((value(v("/S<9>" ?result "tran") 5.6e-08) + 0.1))) + (1024 * round((value(v("/S<10>" ?result "tran") 5.6e-08) + 0.1))) + (2048 * round((value(v("/S<11>" ?result "tran") 5.6e-08) + 0.1))) + (4096 * round((value(v("/S<12>" ?result "tran") 5.6e-08) + 0.1))) + (8192 * round((value(v("/S<13>" ?result "tran") 5.6e-08) + 0.1))) + (16384 * round((value(v("/S<14>" ?result "tran") 5.6e-08) + 0.1))) + (16384 * round((value(v("/S<15>" ?result "tran") 5.6e-08) + 0.1))) + (16384 * round((value(v("/S<15>" ?result "tran") 5.6e-08) + 0.1))) + (16384 * round((value(v("/Cout" ?result "tran") 5.6e-08) + 0.1))) + (16384 * round((value(v("/Cout" ?result "tran") 5.6e-08) + 0.1))) + (16384 * round((value(v("/Cout" ?result "tran") 5.6e-08) + 0.1))) + (16384 * round((value(v("/Cout" ?result "tran") 5.6e-08) + 0.1)))) - ((1 * round((value(v("/A<0>" ?result "tran") 5.6e-08) + 0.1))) + (2 * round((value(v("/A<1>" ?result "tran") 5.6e-08) + 0.1))) + (4 * round((value(v("/A<2>" ?result "tran") 5.6e-08) + 0.1))) + (8 * round((value(v("/A<3>" ?result "tran") 5.6e-08) + 0.1))) + (16 * round((value(v("/A<4>" ?result "tran") 5.6e-08) + 0.1))) + (32 * round((value(v("/A<5>" ?result "tran") 5.6e-08) + 0.1))) + (64 * round((value(v("/A<6>" ?result "tran") 5.6e-08) + 0.1))) + (128 * round((value(v("/A<7>" ?result "tran") 5.6e-08) + 0.1))) + (256 * round((value(v("/A<8>" ?result "tran") 5.6e-08) + 0.1))) + (512 * round((value(v("/A<9>" ?result "tran") 5.6e-08) + 0.1))) + (1024 * round((value(v("/A<10>" ?result "tran") 5.6e-08) + 0.1))) + (2048 * round((value(v("/A<11>" ?result "tran") 5.6e-08) + 0.1))) + (4096 * round((value(v("/A<12>" ?result "tran") 5.6e-08) + 0.1))) + (8192 * round((value(v("/A<13>" ?result "tran") 5.6e-08) + 0.1))) + (16384 * round((value(v("/A<14>" ?result "tran") 5.6e-08) + 0.1))) + (16384 * round((value(v("/A<15>" ?result "tran") 5.6e-08) + 0.1))) + (16384 * round((value(v("/A<15>" ?result "tran") 5.6e-08) + 0.1))) + (1 * round((value(v("/B<0>" ?result "tran") 5.6e-08) + 0.1))) + (2 * round((value(v("/B<1>" ?result "tran") 5.6e-08) + 0.1))) + (4 * round((value(v("/B<2>" ?result "tran") 5.6e-08) + 0.1))) + (8 * round((value(v("/B<3>" ?result "tran") 5.6e-08) + 0.1))) + (16 * round((value(v("/B<4>" ?result "tran") 5.6e-08) + 0.1))) + (32 * round((value(v("/B<5>" ?result "tran") 5.6e-08) + 0.1))) + (64 * round((value(v("/B<6>" ?result "tran") 5.6e-08) + 0.1))) + (128 * round((value(v("/B<7>" ?result "tran") 5.6e-08) + 0.1))) + (256 * round((value(v("/B<8>" ?result "tran") 5.6e-08) + 0.1))) + (512 * round((value(v("/B<9>" ?result "tran") 5.6e-08) + 0.1))) + (1024 * round((value(v("/B<10>" ?result "tran") 5.6e-08) + 0.1))) + (2048 * round((value(v("/B<11>" ?result "tran") 5.6e-08) + 0.1))) + (4096 * round((value(v("/B<12>" ?result "tran") 5.6e-08) + 0.1))) + (8192 * round((value(v("/B<13>" ?result "tran") 5.6e-08) + 0.1))) + (16384 * round((value(v("/B<14>" ?result "tran") 5.6e-08) + 0.1))) + (16384 * round((value(v("/B<15>" ?result "tran") 5.6e-08) + 0.1))) + (16384 * round((value(v("/B<15>" ?result "tran") 5.6e-08) + 0.1))) + round((value(v("/Cin" ?result "tran") 5.6e-08) + 0.1))))
  Output E33 = (((1 * round((value(v("/S<0>" ?result "tran") 5.8e-08) + 0.1))) + (2 * round((value(v("/S<1>" ?result "tran") 5.8e-08) + 0.1))) + (4 * round((value(v("/S<2>" ?result "tran") 5.8e-08) + 0.1))) + (8 * round((value(v("/S<3>" ?result "tran") 5.8e-08) + 0.1))) + (16 * round((value(v("/S<4>" ?result "tran") 5.8e-08) + 0.1))) + (32 * round((value(v("/S<5>" ?result "tran") 5.8e-08) + 0.1))) + (64 * round((value(v("/S<6>" ?result "tran") 5.8e-08) + 0.1))) + (128 * round((value(v("/S<7>" ?result "tran") 5.8e-08) + 0.1))) + (256 * round((value(v("/S<8>" ?result "tran") 5.8e-08) + 0.1))) + (512 * round((value(v("/S<9>" ?result "tran") 5.8e-08) + 0.1))) + (1024 * round((value(v("/S<10>" ?result "tran") 5.8e-08) + 0.1))) + (2048 * round((value(v("/S<11>" ?result "tran") 5.8e-08) + 0.1))) + (4096 * round((value(v("/S<12>" ?result "tran") 5.8e-08) + 0.1))) + (8192 * round((value(v("/S<13>" ?result "tran") 5.8e-08) + 0.1))) + (16384 * round((value(v("/S<14>" ?result "tran") 5.8e-08) + 0.1))) + (16384 * round((value(v("/S<15>" ?result "tran") 5.8e-08) + 0.1))) + (16384 * round((value(v("/S<15>" ?result "tran") 5.8e-08) + 0.1))) + (16384 * round((value(v("/Cout" ?result "tran") 5.8e-08) + 0.1))) + (16384 * round((value(v("/Cout" ?result "tran") 5.8e-08) + 0.1))) + (16384 * round((value(v("/Cout" ?result "tran") 5.8e-08) + 0.1))) + (16384 * round((value(v("/Cout" ?result "tran") 5.8e-08) + 0.1)))) - ((1 * round((value(v("/A<0>" ?result "tran") 5.8e-08) + 0.1))) + (2 * round((value(v("/A<1>" ?result "tran") 5.8e-08) + 0.1))) + (4 * round((value(v("/A<2>" ?result "tran") 5.8e-08) + 0.1))) + (8 * round((value(v("/A<3>" ?result "tran") 5.8e-08) + 0.1))) + (16 * round((value(v("/A<4>" ?result "tran") 5.8e-08) + 0.1))) + (32 * round((value(v("/A<5>" ?result "tran") 5.8e-08) + 0.1))) + (64 * round((value(v("/A<6>" ?result "tran") 5.8e-08) + 0.1))) + (128 * round((value(v("/A<7>" ?result "tran") 5.8e-08) + 0.1))) + (256 * round((value(v("/A<8>" ?result "tran") 5.8e-08) + 0.1))) + (512 * round((value(v("/A<9>" ?result "tran") 5.8e-08) + 0.1))) + (1024 * round((value(v("/A<10>" ?result "tran") 5.8e-08) + 0.1))) + (2048 * round((value(v("/A<11>" ?result "tran") 5.8e-08) + 0.1))) + (4096 * round((value(v("/A<12>" ?result "tran") 5.8e-08) + 0.1))) + (8192 * round((value(v("/A<13>" ?result "tran") 5.8e-08) + 0.1))) + (16384 * round((value(v("/A<14>" ?result "tran") 5.8e-08) + 0.1))) + (16384 * round((value(v("/A<15>" ?result "tran") 5.8e-08) + 0.1))) + (16384 * round((value(v("/A<15>" ?result "tran") 5.8e-08) + 0.1))) + (1 * round((value(v("/B<0>" ?result "tran") 5.8e-08) + 0.1))) + (2 * round((value(v("/B<1>" ?result "tran") 5.8e-08) + 0.1))) + (4 * round((value(v("/B<2>" ?result "tran") 5.8e-08) + 0.1))) + (8 * round((value(v("/B<3>" ?result "tran") 5.8e-08) + 0.1))) + (16 * round((value(v("/B<4>" ?result "tran") 5.8e-08) + 0.1))) + (32 * round((value(v("/B<5>" ?result "tran") 5.8e-08) + 0.1))) + (64 * round((value(v("/B<6>" ?result "tran") 5.8e-08) + 0.1))) + (128 * round((value(v("/B<7>" ?result "tran") 5.8e-08) + 0.1))) + (256 * round((value(v("/B<8>" ?result "tran") 5.8e-08) + 0.1))) + (512 * round((value(v("/B<9>" ?result "tran") 5.8e-08) + 0.1))) + (1024 * round((value(v("/B<10>" ?result "tran") 5.8e-08) + 0.1))) + (2048 * round((value(v("/B<11>" ?result "tran") 5.8e-08) + 0.1))) + (4096 * round((value(v("/B<12>" ?result "tran") 5.8e-08) + 0.1))) + (8192 * round((value(v("/B<13>" ?result "tran") 5.8e-08) + 0.1))) + (16384 * round((value(v("/B<14>" ?result "tran") 5.8e-08) + 0.1))) + (16384 * round((value(v("/B<15>" ?result "tran") 5.8e-08) + 0.1))) + (16384 * round((value(v("/B<15>" ?result "tran") 5.8e-08) + 0.1))) + round((value(v("/Cin" ?result "tran") 5.8e-08) + 0.1))))
  Output E34 = (((1 * round((value(v("/S<0>" ?result "tran") 6e-08) + 0.1))) + (2 * round((value(v("/S<1>" ?result "tran") 6e-08) + 0.1))) + (4 * round((value(v("/S<2>" ?result "tran") 6e-08) + 0.1))) + (8 * round((value(v("/S<3>" ?result "tran") 6e-08) + 0.1))) + (16 * round((value(v("/S<4>" ?result "tran") 6e-08) + 0.1))) + (32 * round((value(v("/S<5>" ?result "tran") 6e-08) + 0.1))) + (64 * round((value(v("/S<6>" ?result "tran") 6e-08) + 0.1))) + (128 * round((value(v("/S<7>" ?result "tran") 6e-08) + 0.1))) + (256 * round((value(v("/S<8>" ?result "tran") 6e-08) + 0.1))) + (512 * round((value(v("/S<9>" ?result "tran") 6e-08) + 0.1))) + (1024 * round((value(v("/S<10>" ?result "tran") 6e-08) + 0.1))) + (2048 * round((value(v("/S<11>" ?result "tran") 6e-08) + 0.1))) + (4096 * round((value(v("/S<12>" ?result "tran") 6e-08) + 0.1))) + (8192 * round((value(v("/S<13>" ?result "tran") 6e-08) + 0.1))) + (16384 * round((value(v("/S<14>" ?result "tran") 6e-08) + 0.1))) + (16384 * round((value(v("/S<15>" ?result "tran") 6e-08) + 0.1))) + (16384 * round((value(v("/S<15>" ?result "tran") 6e-08) + 0.1))) + (16384 * round((value(v("/Cout" ?result "tran") 6e-08) + 0.1))) + (16384 * round((value(v("/Cout" ?result "tran") 6e-08) + 0.1))) + (16384 * round((value(v("/Cout" ?result "tran") 6e-08) + 0.1))) + (16384 * round((value(v("/Cout" ?result "tran") 6e-08) + 0.1)))) - ((1 * round((value(v("/A<0>" ?result "tran") 6e-08) + 0.1))) + (2 * round((value(v("/A<1>" ?result "tran") 6e-08) + 0.1))) + (4 * round((value(v("/A<2>" ?result "tran") 6e-08) + 0.1))) + (8 * round((value(v("/A<3>" ?result "tran") 6e-08) + 0.1))) + (16 * round((value(v("/A<4>" ?result "tran") 6e-08) + 0.1))) + (32 * round((value(v("/A<5>" ?result "tran") 6e-08) + 0.1))) + (64 * round((value(v("/A<6>" ?result "tran") 6e-08) + 0.1))) + (128 * round((value(v("/A<7>" ?result "tran") 6e-08) + 0.1))) + (256 * round((value(v("/A<8>" ?result "tran") 6e-08) + 0.1))) + (512 * round((value(v("/A<9>" ?result "tran") 6e-08) + 0.1))) + (1024 * round((value(v("/A<10>" ?result "tran") 6e-08) + 0.1))) + (2048 * round((value(v("/A<11>" ?result "tran") 6e-08) + 0.1))) + (4096 * round((value(v("/A<12>" ?result "tran") 6e-08) + 0.1))) + (8192 * round((value(v("/A<13>" ?result "tran") 6e-08) + 0.1))) + (16384 * round((value(v("/A<14>" ?result "tran") 6e-08) + 0.1))) + (16384 * round((value(v("/A<15>" ?result "tran") 6e-08) + 0.1))) + (16384 * round((value(v("/A<15>" ?result "tran") 6e-08) + 0.1))) + (1 * round((value(v("/B<0>" ?result "tran") 6e-08) + 0.1))) + (2 * round((value(v("/B<1>" ?result "tran") 6e-08) + 0.1))) + (4 * round((value(v("/B<2>" ?result "tran") 6e-08) + 0.1))) + (8 * round((value(v("/B<3>" ?result "tran") 6e-08) + 0.1))) + (16 * round((value(v("/B<4>" ?result "tran") 6e-08) + 0.1))) + (32 * round((value(v("/B<5>" ?result "tran") 6e-08) + 0.1))) + (64 * round((value(v("/B<6>" ?result "tran") 6e-08) + 0.1))) + (128 * round((value(v("/B<7>" ?result "tran") 6e-08) + 0.1))) + (256 * round((value(v("/B<8>" ?result "tran") 6e-08) + 0.1))) + (512 * round((value(v("/B<9>" ?result "tran") 6e-08) + 0.1))) + (1024 * round((value(v("/B<10>" ?result "tran") 6e-08) + 0.1))) + (2048 * round((value(v("/B<11>" ?result "tran") 6e-08) + 0.1))) + (4096 * round((value(v("/B<12>" ?result "tran") 6e-08) + 0.1))) + (8192 * round((value(v("/B<13>" ?result "tran") 6e-08) + 0.1))) + (16384 * round((value(v("/B<14>" ?result "tran") 6e-08) + 0.1))) + (16384 * round((value(v("/B<15>" ?result "tran") 6e-08) + 0.1))) + (16384 * round((value(v("/B<15>" ?result "tran") 6e-08) + 0.1))) + round((value(v("/Cin" ?result "tran") 6e-08) + 0.1))))
  Output E35 = (((1 * round((value(v("/S<0>" ?result "tran") 6.2e-08) + 0.1))) + (2 * round((value(v("/S<1>" ?result "tran") 6.2e-08) + 0.1))) + (4 * round((value(v("/S<2>" ?result "tran") 6.2e-08) + 0.1))) + (8 * round((value(v("/S<3>" ?result "tran") 6.2e-08) + 0.1))) + (16 * round((value(v("/S<4>" ?result "tran") 6.2e-08) + 0.1))) + (32 * round((value(v("/S<5>" ?result "tran") 6.2e-08) + 0.1))) + (64 * round((value(v("/S<6>" ?result "tran") 6.2e-08) + 0.1))) + (128 * round((value(v("/S<7>" ?result "tran") 6.2e-08) + 0.1))) + (256 * round((value(v("/S<8>" ?result "tran") 6.2e-08) + 0.1))) + (512 * round((value(v("/S<9>" ?result "tran") 6.2e-08) + 0.1))) + (1024 * round((value(v("/S<10>" ?result "tran") 6.2e-08) + 0.1))) + (2048 * round((value(v("/S<11>" ?result "tran") 6.2e-08) + 0.1))) + (4096 * round((value(v("/S<12>" ?result "tran") 6.2e-08) + 0.1))) + (8192 * round((value(v("/S<13>" ?result "tran") 6.2e-08) + 0.1))) + (16384 * round((value(v("/S<14>" ?result "tran") 6.2e-08) + 0.1))) + (16384 * round((value(v("/S<15>" ?result "tran") 6.2e-08) + 0.1))) + (16384 * round((value(v("/S<15>" ?result "tran") 6.2e-08) + 0.1))) + (16384 * round((value(v("/Cout" ?result "tran") 6.2e-08) + 0.1))) + (16384 * round((value(v("/Cout" ?result "tran") 6.2e-08) + 0.1))) + (16384 * round((value(v("/Cout" ?result "tran") 6.2e-08) + 0.1))) + (16384 * round((value(v("/Cout" ?result "tran") 6.2e-08) + 0.1)))) - ((1 * round((value(v("/A<0>" ?result "tran") 6.2e-08) + 0.1))) + (2 * round((value(v("/A<1>" ?result "tran") 6.2e-08) + 0.1))) + (4 * round((value(v("/A<2>" ?result "tran") 6.2e-08) + 0.1))) + (8 * round((value(v("/A<3>" ?result "tran") 6.2e-08) + 0.1))) + (16 * round((value(v("/A<4>" ?result "tran") 6.2e-08) + 0.1))) + (32 * round((value(v("/A<5>" ?result "tran") 6.2e-08) + 0.1))) + (64 * round((value(v("/A<6>" ?result "tran") 6.2e-08) + 0.1))) + (128 * round((value(v("/A<7>" ?result "tran") 6.2e-08) + 0.1))) + (256 * round((value(v("/A<8>" ?result "tran") 6.2e-08) + 0.1))) + (512 * round((value(v("/A<9>" ?result "tran") 6.2e-08) + 0.1))) + (1024 * round((value(v("/A<10>" ?result "tran") 6.2e-08) + 0.1))) + (2048 * round((value(v("/A<11>" ?result "tran") 6.2e-08) + 0.1))) + (4096 * round((value(v("/A<12>" ?result "tran") 6.2e-08) + 0.1))) + (8192 * round((value(v("/A<13>" ?result "tran") 6.2e-08) + 0.1))) + (16384 * round((value(v("/A<14>" ?result "tran") 6.2e-08) + 0.1))) + (16384 * round((value(v("/A<15>" ?result "tran") 6.2e-08) + 0.1))) + (16384 * round((value(v("/A<15>" ?result "tran") 6.2e-08) + 0.1))) + (1 * round((value(v("/B<0>" ?result "tran") 6.2e-08) + 0.1))) + (2 * round((value(v("/B<1>" ?result "tran") 6.2e-08) + 0.1))) + (4 * round((value(v("/B<2>" ?result "tran") 6.2e-08) + 0.1))) + (8 * round((value(v("/B<3>" ?result "tran") 6.2e-08) + 0.1))) + (16 * round((value(v("/B<4>" ?result "tran") 6.2e-08) + 0.1))) + (32 * round((value(v("/B<5>" ?result "tran") 6.2e-08) + 0.1))) + (64 * round((value(v("/B<6>" ?result "tran") 6.2e-08) + 0.1))) + (128 * round((value(v("/B<7>" ?result "tran") 6.2e-08) + 0.1))) + (256 * round((value(v("/B<8>" ?result "tran") 6.2e-08) + 0.1))) + (512 * round((value(v("/B<9>" ?result "tran") 6.2e-08) + 0.1))) + (1024 * round((value(v("/B<10>" ?result "tran") 6.2e-08) + 0.1))) + (2048 * round((value(v("/B<11>" ?result "tran") 6.2e-08) + 0.1))) + (4096 * round((value(v("/B<12>" ?result "tran") 6.2e-08) + 0.1))) + (8192 * round((value(v("/B<13>" ?result "tran") 6.2e-08) + 0.1))) + (16384 * round((value(v("/B<14>" ?result "tran") 6.2e-08) + 0.1))) + (16384 * round((value(v("/B<15>" ?result "tran") 6.2e-08) + 0.1))) + (16384 * round((value(v("/B<15>" ?result "tran") 6.2e-08) + 0.1))) + round((value(v("/Cin" ?result "tran") 6.2e-08) + 0.1))))
  Output E36 = (((1 * round((value(v("/S<0>" ?result "tran") 6.4e-08) + 0.1))) + (2 * round((value(v("/S<1>" ?result "tran") 6.4e-08) + 0.1))) + (4 * round((value(v("/S<2>" ?result "tran") 6.4e-08) + 0.1))) + (8 * round((value(v("/S<3>" ?result "tran") 6.4e-08) + 0.1))) + (16 * round((value(v("/S<4>" ?result "tran") 6.4e-08) + 0.1))) + (32 * round((value(v("/S<5>" ?result "tran") 6.4e-08) + 0.1))) + (64 * round((value(v("/S<6>" ?result "tran") 6.4e-08) + 0.1))) + (128 * round((value(v("/S<7>" ?result "tran") 6.4e-08) + 0.1))) + (256 * round((value(v("/S<8>" ?result "tran") 6.4e-08) + 0.1))) + (512 * round((value(v("/S<9>" ?result "tran") 6.4e-08) + 0.1))) + (1024 * round((value(v("/S<10>" ?result "tran") 6.4e-08) + 0.1))) + (2048 * round((value(v("/S<11>" ?result "tran") 6.4e-08) + 0.1))) + (4096 * round((value(v("/S<12>" ?result "tran") 6.4e-08) + 0.1))) + (8192 * round((value(v("/S<13>" ?result "tran") 6.4e-08) + 0.1))) + (16384 * round((value(v("/S<14>" ?result "tran") 6.4e-08) + 0.1))) + (16384 * round((value(v("/S<15>" ?result "tran") 6.4e-08) + 0.1))) + (16384 * round((value(v("/S<15>" ?result "tran") 6.4e-08) + 0.1))) + (16384 * round((value(v("/Cout" ?result "tran") 6.4e-08) + 0.1))) + (16384 * round((value(v("/Cout" ?result "tran") 6.4e-08) + 0.1))) + (16384 * round((value(v("/Cout" ?result "tran") 6.4e-08) + 0.1))) + (16384 * round((value(v("/Cout" ?result "tran") 6.4e-08) + 0.1)))) - ((1 * round((value(v("/A<0>" ?result "tran") 6.4e-08) + 0.1))) + (2 * round((value(v("/A<1>" ?result "tran") 6.4e-08) + 0.1))) + (4 * round((value(v("/A<2>" ?result "tran") 6.4e-08) + 0.1))) + (8 * round((value(v("/A<3>" ?result "tran") 6.4e-08) + 0.1))) + (16 * round((value(v("/A<4>" ?result "tran") 6.4e-08) + 0.1))) + (32 * round((value(v("/A<5>" ?result "tran") 6.4e-08) + 0.1))) + (64 * round((value(v("/A<6>" ?result "tran") 6.4e-08) + 0.1))) + (128 * round((value(v("/A<7>" ?result "tran") 6.4e-08) + 0.1))) + (256 * round((value(v("/A<8>" ?result "tran") 6.4e-08) + 0.1))) + (512 * round((value(v("/A<9>" ?result "tran") 6.4e-08) + 0.1))) + (1024 * round((value(v("/A<10>" ?result "tran") 6.4e-08) + 0.1))) + (2048 * round((value(v("/A<11>" ?result "tran") 6.4e-08) + 0.1))) + (4096 * round((value(v("/A<12>" ?result "tran") 6.4e-08) + 0.1))) + (8192 * round((value(v("/A<13>" ?result "tran") 6.4e-08) + 0.1))) + (16384 * round((value(v("/A<14>" ?result "tran") 6.4e-08) + 0.1))) + (16384 * round((value(v("/A<15>" ?result "tran") 6.4e-08) + 0.1))) + (16384 * round((value(v("/A<15>" ?result "tran") 6.4e-08) + 0.1))) + (1 * round((value(v("/B<0>" ?result "tran") 6.4e-08) + 0.1))) + (2 * round((value(v("/B<1>" ?result "tran") 6.4e-08) + 0.1))) + (4 * round((value(v("/B<2>" ?result "tran") 6.4e-08) + 0.1))) + (8 * round((value(v("/B<3>" ?result "tran") 6.4e-08) + 0.1))) + (16 * round((value(v("/B<4>" ?result "tran") 6.4e-08) + 0.1))) + (32 * round((value(v("/B<5>" ?result "tran") 6.4e-08) + 0.1))) + (64 * round((value(v("/B<6>" ?result "tran") 6.4e-08) + 0.1))) + (128 * round((value(v("/B<7>" ?result "tran") 6.4e-08) + 0.1))) + (256 * round((value(v("/B<8>" ?result "tran") 6.4e-08) + 0.1))) + (512 * round((value(v("/B<9>" ?result "tran") 6.4e-08) + 0.1))) + (1024 * round((value(v("/B<10>" ?result "tran") 6.4e-08) + 0.1))) + (2048 * round((value(v("/B<11>" ?result "tran") 6.4e-08) + 0.1))) + (4096 * round((value(v("/B<12>" ?result "tran") 6.4e-08) + 0.1))) + (8192 * round((value(v("/B<13>" ?result "tran") 6.4e-08) + 0.1))) + (16384 * round((value(v("/B<14>" ?result "tran") 6.4e-08) + 0.1))) + (16384 * round((value(v("/B<15>" ?result "tran") 6.4e-08) + 0.1))) + (16384 * round((value(v("/B<15>" ?result "tran") 6.4e-08) + 0.1))) + round((value(v("/Cin" ?result "tran") 6.4e-08) + 0.1))))
  Output E37 = (((1 * round((value(v("/S<0>" ?result "tran") 6.6e-08) + 0.1))) + (2 * round((value(v("/S<1>" ?result "tran") 6.6e-08) + 0.1))) + (4 * round((value(v("/S<2>" ?result "tran") 6.6e-08) + 0.1))) + (8 * round((value(v("/S<3>" ?result "tran") 6.6e-08) + 0.1))) + (16 * round((value(v("/S<4>" ?result "tran") 6.6e-08) + 0.1))) + (32 * round((value(v("/S<5>" ?result "tran") 6.6e-08) + 0.1))) + (64 * round((value(v("/S<6>" ?result "tran") 6.6e-08) + 0.1))) + (128 * round((value(v("/S<7>" ?result "tran") 6.6e-08) + 0.1))) + (256 * round((value(v("/S<8>" ?result "tran") 6.6e-08) + 0.1))) + (512 * round((value(v("/S<9>" ?result "tran") 6.6e-08) + 0.1))) + (1024 * round((value(v("/S<10>" ?result "tran") 6.6e-08) + 0.1))) + (2048 * round((value(v("/S<11>" ?result "tran") 6.6e-08) + 0.1))) + (4096 * round((value(v("/S<12>" ?result "tran") 6.6e-08) + 0.1))) + (8192 * round((value(v("/S<13>" ?result "tran") 6.6e-08) + 0.1))) + (16384 * round((value(v("/S<14>" ?result "tran") 6.6e-08) + 0.1))) + (16384 * round((value(v("/S<15>" ?result "tran") 6.6e-08) + 0.1))) + (16384 * round((value(v("/S<15>" ?result "tran") 6.6e-08) + 0.1))) + (16384 * round((value(v("/Cout" ?result "tran") 6.6e-08) + 0.1))) + (16384 * round((value(v("/Cout" ?result "tran") 6.6e-08) + 0.1))) + (16384 * round((value(v("/Cout" ?result "tran") 6.6e-08) + 0.1))) + (16384 * round((value(v("/Cout" ?result "tran") 6.6e-08) + 0.1)))) - ((1 * round((value(v("/A<0>" ?result "tran") 6.6e-08) + 0.1))) + (2 * round((value(v("/A<1>" ?result "tran") 6.6e-08) + 0.1))) + (4 * round((value(v("/A<2>" ?result "tran") 6.6e-08) + 0.1))) + (8 * round((value(v("/A<3>" ?result "tran") 6.6e-08) + 0.1))) + (16 * round((value(v("/A<4>" ?result "tran") 6.6e-08) + 0.1))) + (32 * round((value(v("/A<5>" ?result "tran") 6.6e-08) + 0.1))) + (64 * round((value(v("/A<6>" ?result "tran") 6.6e-08) + 0.1))) + (128 * round((value(v("/A<7>" ?result "tran") 6.6e-08) + 0.1))) + (256 * round((value(v("/A<8>" ?result "tran") 6.6e-08) + 0.1))) + (512 * round((value(v("/A<9>" ?result "tran") 6.6e-08) + 0.1))) + (1024 * round((value(v("/A<10>" ?result "tran") 6.6e-08) + 0.1))) + (2048 * round((value(v("/A<11>" ?result "tran") 6.6e-08) + 0.1))) + (4096 * round((value(v("/A<12>" ?result "tran") 6.6e-08) + 0.1))) + (8192 * round((value(v("/A<13>" ?result "tran") 6.6e-08) + 0.1))) + (16384 * round((value(v("/A<14>" ?result "tran") 6.6e-08) + 0.1))) + (16384 * round((value(v("/A<15>" ?result "tran") 6.6e-08) + 0.1))) + (16384 * round((value(v("/A<15>" ?result "tran") 6.6e-08) + 0.1))) + (1 * round((value(v("/B<0>" ?result "tran") 6.6e-08) + 0.1))) + (2 * round((value(v("/B<1>" ?result "tran") 6.6e-08) + 0.1))) + (4 * round((value(v("/B<2>" ?result "tran") 6.6e-08) + 0.1))) + (8 * round((value(v("/B<3>" ?result "tran") 6.6e-08) + 0.1))) + (16 * round((value(v("/B<4>" ?result "tran") 6.6e-08) + 0.1))) + (32 * round((value(v("/B<5>" ?result "tran") 6.6e-08) + 0.1))) + (64 * round((value(v("/B<6>" ?result "tran") 6.6e-08) + 0.1))) + (128 * round((value(v("/B<7>" ?result "tran") 6.6e-08) + 0.1))) + (256 * round((value(v("/B<8>" ?result "tran") 6.6e-08) + 0.1))) + (512 * round((value(v("/B<9>" ?result "tran") 6.6e-08) + 0.1))) + (1024 * round((value(v("/B<10>" ?result "tran") 6.6e-08) + 0.1))) + (2048 * round((value(v("/B<11>" ?result "tran") 6.6e-08) + 0.1))) + (4096 * round((value(v("/B<12>" ?result "tran") 6.6e-08) + 0.1))) + (8192 * round((value(v("/B<13>" ?result "tran") 6.6e-08) + 0.1))) + (16384 * round((value(v("/B<14>" ?result "tran") 6.6e-08) + 0.1))) + (16384 * round((value(v("/B<15>" ?result "tran") 6.6e-08) + 0.1))) + (16384 * round((value(v("/B<15>" ?result "tran") 6.6e-08) + 0.1))) + round((value(v("/Cin" ?result "tran") 6.6e-08) + 0.1))))
  Output E38 = (((1 * round((value(v("/S<0>" ?result "tran") 6.8e-08) + 0.1))) + (2 * round((value(v("/S<1>" ?result "tran") 6.8e-08) + 0.1))) + (4 * round((value(v("/S<2>" ?result "tran") 6.8e-08) + 0.1))) + (8 * round((value(v("/S<3>" ?result "tran") 6.8e-08) + 0.1))) + (16 * round((value(v("/S<4>" ?result "tran") 6.8e-08) + 0.1))) + (32 * round((value(v("/S<5>" ?result "tran") 6.8e-08) + 0.1))) + (64 * round((value(v("/S<6>" ?result "tran") 6.8e-08) + 0.1))) + (128 * round((value(v("/S<7>" ?result "tran") 6.8e-08) + 0.1))) + (256 * round((value(v("/S<8>" ?result "tran") 6.8e-08) + 0.1))) + (512 * round((value(v("/S<9>" ?result "tran") 6.8e-08) + 0.1))) + (1024 * round((value(v("/S<10>" ?result "tran") 6.8e-08) + 0.1))) + (2048 * round((value(v("/S<11>" ?result "tran") 6.8e-08) + 0.1))) + (4096 * round((value(v("/S<12>" ?result "tran") 6.8e-08) + 0.1))) + (8192 * round((value(v("/S<13>" ?result "tran") 6.8e-08) + 0.1))) + (16384 * round((value(v("/S<14>" ?result "tran") 6.8e-08) + 0.1))) + (16384 * round((value(v("/S<15>" ?result "tran") 6.8e-08) + 0.1))) + (16384 * round((value(v("/S<15>" ?result "tran") 6.8e-08) + 0.1))) + (16384 * round((value(v("/Cout" ?result "tran") 6.8e-08) + 0.1))) + (16384 * round((value(v("/Cout" ?result "tran") 6.8e-08) + 0.1))) + (16384 * round((value(v("/Cout" ?result "tran") 6.8e-08) + 0.1))) + (16384 * round((value(v("/Cout" ?result "tran") 6.8e-08) + 0.1)))) - ((1 * round((value(v("/A<0>" ?result "tran") 6.8e-08) + 0.1))) + (2 * round((value(v("/A<1>" ?result "tran") 6.8e-08) + 0.1))) + (4 * round((value(v("/A<2>" ?result "tran") 6.8e-08) + 0.1))) + (8 * round((value(v("/A<3>" ?result "tran") 6.8e-08) + 0.1))) + (16 * round((value(v("/A<4>" ?result "tran") 6.8e-08) + 0.1))) + (32 * round((value(v("/A<5>" ?result "tran") 6.8e-08) + 0.1))) + (64 * round((value(v("/A<6>" ?result "tran") 6.8e-08) + 0.1))) + (128 * round((value(v("/A<7>" ?result "tran") 6.8e-08) + 0.1))) + (256 * round((value(v("/A<8>" ?result "tran") 6.8e-08) + 0.1))) + (512 * round((value(v("/A<9>" ?result "tran") 6.8e-08) + 0.1))) + (1024 * round((value(v("/A<10>" ?result "tran") 6.8e-08) + 0.1))) + (2048 * round((value(v("/A<11>" ?result "tran") 6.8e-08) + 0.1))) + (4096 * round((value(v("/A<12>" ?result "tran") 6.8e-08) + 0.1))) + (8192 * round((value(v("/A<13>" ?result "tran") 6.8e-08) + 0.1))) + (16384 * round((value(v("/A<14>" ?result "tran") 6.8e-08) + 0.1))) + (16384 * round((value(v("/A<15>" ?result "tran") 6.8e-08) + 0.1))) + (16384 * round((value(v("/A<15>" ?result "tran") 6.8e-08) + 0.1))) + (1 * round((value(v("/B<0>" ?result "tran") 6.8e-08) + 0.1))) + (2 * round((value(v("/B<1>" ?result "tran") 6.8e-08) + 0.1))) + (4 * round((value(v("/B<2>" ?result "tran") 6.8e-08) + 0.1))) + (8 * round((value(v("/B<3>" ?result "tran") 6.8e-08) + 0.1))) + (16 * round((value(v("/B<4>" ?result "tran") 6.8e-08) + 0.1))) + (32 * round((value(v("/B<5>" ?result "tran") 6.8e-08) + 0.1))) + (64 * round((value(v("/B<6>" ?result "tran") 6.8e-08) + 0.1))) + (128 * round((value(v("/B<7>" ?result "tran") 6.8e-08) + 0.1))) + (256 * round((value(v("/B<8>" ?result "tran") 6.8e-08) + 0.1))) + (512 * round((value(v("/B<9>" ?result "tran") 6.8e-08) + 0.1))) + (1024 * round((value(v("/B<10>" ?result "tran") 6.8e-08) + 0.1))) + (2048 * round((value(v("/B<11>" ?result "tran") 6.8e-08) + 0.1))) + (4096 * round((value(v("/B<12>" ?result "tran") 6.8e-08) + 0.1))) + (8192 * round((value(v("/B<13>" ?result "tran") 6.8e-08) + 0.1))) + (16384 * round((value(v("/B<14>" ?result "tran") 6.8e-08) + 0.1))) + (16384 * round((value(v("/B<15>" ?result "tran") 6.8e-08) + 0.1))) + (16384 * round((value(v("/B<15>" ?result "tran") 6.8e-08) + 0.1))) + round((value(v("/Cin" ?result "tran") 6.8e-08) + 0.1))))
  Output E39 = (((1 * round((value(v("/S<0>" ?result "tran") 7e-08) + 0.1))) + (2 * round((value(v("/S<1>" ?result "tran") 7e-08) + 0.1))) + (4 * round((value(v("/S<2>" ?result "tran") 7e-08) + 0.1))) + (8 * round((value(v("/S<3>" ?result "tran") 7e-08) + 0.1))) + (16 * round((value(v("/S<4>" ?result "tran") 7e-08) + 0.1))) + (32 * round((value(v("/S<5>" ?result "tran") 7e-08) + 0.1))) + (64 * round((value(v("/S<6>" ?result "tran") 7e-08) + 0.1))) + (128 * round((value(v("/S<7>" ?result "tran") 7e-08) + 0.1))) + (256 * round((value(v("/S<8>" ?result "tran") 7e-08) + 0.1))) + (512 * round((value(v("/S<9>" ?result "tran") 7e-08) + 0.1))) + (1024 * round((value(v("/S<10>" ?result "tran") 7e-08) + 0.1))) + (2048 * round((value(v("/S<11>" ?result "tran") 7e-08) + 0.1))) + (4096 * round((value(v("/S<12>" ?result "tran") 7e-08) + 0.1))) + (8192 * round((value(v("/S<13>" ?result "tran") 7e-08) + 0.1))) + (16384 * round((value(v("/S<14>" ?result "tran") 7e-08) + 0.1))) + (16384 * round((value(v("/S<15>" ?result "tran") 7e-08) + 0.1))) + (16384 * round((value(v("/S<15>" ?result "tran") 7e-08) + 0.1))) + (16384 * round((value(v("/Cout" ?result "tran") 7e-08) + 0.1))) + (16384 * round((value(v("/Cout" ?result "tran") 7e-08) + 0.1))) + (16384 * round((value(v("/Cout" ?result "tran") 7e-08) + 0.1))) + (16384 * round((value(v("/Cout" ?result "tran") 7e-08) + 0.1)))) - ((1 * round((value(v("/A<0>" ?result "tran") 7e-08) + 0.1))) + (2 * round((value(v("/A<1>" ?result "tran") 7e-08) + 0.1))) + (4 * round((value(v("/A<2>" ?result "tran") 7e-08) + 0.1))) + (8 * round((value(v("/A<3>" ?result "tran") 7e-08) + 0.1))) + (16 * round((value(v("/A<4>" ?result "tran") 7e-08) + 0.1))) + (32 * round((value(v("/A<5>" ?result "tran") 7e-08) + 0.1))) + (64 * round((value(v("/A<6>" ?result "tran") 7e-08) + 0.1))) + (128 * round((value(v("/A<7>" ?result "tran") 7e-08) + 0.1))) + (256 * round((value(v("/A<8>" ?result "tran") 7e-08) + 0.1))) + (512 * round((value(v("/A<9>" ?result "tran") 7e-08) + 0.1))) + (1024 * round((value(v("/A<10>" ?result "tran") 7e-08) + 0.1))) + (2048 * round((value(v("/A<11>" ?result "tran") 7e-08) + 0.1))) + (4096 * round((value(v("/A<12>" ?result "tran") 7e-08) + 0.1))) + (8192 * round((value(v("/A<13>" ?result "tran") 7e-08) + 0.1))) + (16384 * round((value(v("/A<14>" ?result "tran") 7e-08) + 0.1))) + (16384 * round((value(v("/A<15>" ?result "tran") 7e-08) + 0.1))) + (16384 * round((value(v("/A<15>" ?result "tran") 7e-08) + 0.1))) + (1 * round((value(v("/B<0>" ?result "tran") 7e-08) + 0.1))) + (2 * round((value(v("/B<1>" ?result "tran") 7e-08) + 0.1))) + (4 * round((value(v("/B<2>" ?result "tran") 7e-08) + 0.1))) + (8 * round((value(v("/B<3>" ?result "tran") 7e-08) + 0.1))) + (16 * round((value(v("/B<4>" ?result "tran") 7e-08) + 0.1))) + (32 * round((value(v("/B<5>" ?result "tran") 7e-08) + 0.1))) + (64 * round((value(v("/B<6>" ?result "tran") 7e-08) + 0.1))) + (128 * round((value(v("/B<7>" ?result "tran") 7e-08) + 0.1))) + (256 * round((value(v("/B<8>" ?result "tran") 7e-08) + 0.1))) + (512 * round((value(v("/B<9>" ?result "tran") 7e-08) + 0.1))) + (1024 * round((value(v("/B<10>" ?result "tran") 7e-08) + 0.1))) + (2048 * round((value(v("/B<11>" ?result "tran") 7e-08) + 0.1))) + (4096 * round((value(v("/B<12>" ?result "tran") 7e-08) + 0.1))) + (8192 * round((value(v("/B<13>" ?result "tran") 7e-08) + 0.1))) + (16384 * round((value(v("/B<14>" ?result "tran") 7e-08) + 0.1))) + (16384 * round((value(v("/B<15>" ?result "tran") 7e-08) + 0.1))) + (16384 * round((value(v("/B<15>" ?result "tran") 7e-08) + 0.1))) + round((value(v("/Cin" ?result "tran") 7e-08) + 0.1))))
  Output E40 = (((1 * round((value(v("/S<0>" ?result "tran") 7.2e-08) + 0.1))) + (2 * round((value(v("/S<1>" ?result "tran") 7.2e-08) + 0.1))) + (4 * round((value(v("/S<2>" ?result "tran") 7.2e-08) + 0.1))) + (8 * round((value(v("/S<3>" ?result "tran") 7.2e-08) + 0.1))) + (16 * round((value(v("/S<4>" ?result "tran") 7.2e-08) + 0.1))) + (32 * round((value(v("/S<5>" ?result "tran") 7.2e-08) + 0.1))) + (64 * round((value(v("/S<6>" ?result "tran") 7.2e-08) + 0.1))) + (128 * round((value(v("/S<7>" ?result "tran") 7.2e-08) + 0.1))) + (256 * round((value(v("/S<8>" ?result "tran") 7.2e-08) + 0.1))) + (512 * round((value(v("/S<9>" ?result "tran") 7.2e-08) + 0.1))) + (1024 * round((value(v("/S<10>" ?result "tran") 7.2e-08) + 0.1))) + (2048 * round((value(v("/S<11>" ?result "tran") 7.2e-08) + 0.1))) + (4096 * round((value(v("/S<12>" ?result "tran") 7.2e-08) + 0.1))) + (8192 * round((value(v("/S<13>" ?result "tran") 7.2e-08) + 0.1))) + (16384 * round((value(v("/S<14>" ?result "tran") 7.2e-08) + 0.1))) + (16384 * round((value(v("/S<15>" ?result "tran") 7.2e-08) + 0.1))) + (16384 * round((value(v("/S<15>" ?result "tran") 7.2e-08) + 0.1))) + (16384 * round((value(v("/Cout" ?result "tran") 7.2e-08) + 0.1))) + (16384 * round((value(v("/Cout" ?result "tran") 7.2e-08) + 0.1))) + (16384 * round((value(v("/Cout" ?result "tran") 7.2e-08) + 0.1))) + (16384 * round((value(v("/Cout" ?result "tran") 7.2e-08) + 0.1)))) - ((1 * round((value(v("/A<0>" ?result "tran") 7.2e-08) + 0.1))) + (2 * round((value(v("/A<1>" ?result "tran") 7.2e-08) + 0.1))) + (4 * round((value(v("/A<2>" ?result "tran") 7.2e-08) + 0.1))) + (8 * round((value(v("/A<3>" ?result "tran") 7.2e-08) + 0.1))) + (16 * round((value(v("/A<4>" ?result "tran") 7.2e-08) + 0.1))) + (32 * round((value(v("/A<5>" ?result "tran") 7.2e-08) + 0.1))) + (64 * round((value(v("/A<6>" ?result "tran") 7.2e-08) + 0.1))) + (128 * round((value(v("/A<7>" ?result "tran") 7.2e-08) + 0.1))) + (256 * round((value(v("/A<8>" ?result "tran") 7.2e-08) + 0.1))) + (512 * round((value(v("/A<9>" ?result "tran") 7.2e-08) + 0.1))) + (1024 * round((value(v("/A<10>" ?result "tran") 7.2e-08) + 0.1))) + (2048 * round((value(v("/A<11>" ?result "tran") 7.2e-08) + 0.1))) + (4096 * round((value(v("/A<12>" ?result "tran") 7.2e-08) + 0.1))) + (8192 * round((value(v("/A<13>" ?result "tran") 7.2e-08) + 0.1))) + (16384 * round((value(v("/A<14>" ?result "tran") 7.2e-08) + 0.1))) + (16384 * round((value(v("/A<15>" ?result "tran") 7.2e-08) + 0.1))) + (16384 * round((value(v("/A<15>" ?result "tran") 7.2e-08) + 0.1))) + (1 * round((value(v("/B<0>" ?result "tran") 7.2e-08) + 0.1))) + (2 * round((value(v("/B<1>" ?result "tran") 7.2e-08) + 0.1))) + (4 * round((value(v("/B<2>" ?result "tran") 7.2e-08) + 0.1))) + (8 * round((value(v("/B<3>" ?result "tran") 7.2e-08) + 0.1))) + (16 * round((value(v("/B<4>" ?result "tran") 7.2e-08) + 0.1))) + (32 * round((value(v("/B<5>" ?result "tran") 7.2e-08) + 0.1))) + (64 * round((value(v("/B<6>" ?result "tran") 7.2e-08) + 0.1))) + (128 * round((value(v("/B<7>" ?result "tran") 7.2e-08) + 0.1))) + (256 * round((value(v("/B<8>" ?result "tran") 7.2e-08) + 0.1))) + (512 * round((value(v("/B<9>" ?result "tran") 7.2e-08) + 0.1))) + (1024 * round((value(v("/B<10>" ?result "tran") 7.2e-08) + 0.1))) + (2048 * round((value(v("/B<11>" ?result "tran") 7.2e-08) + 0.1))) + (4096 * round((value(v("/B<12>" ?result "tran") 7.2e-08) + 0.1))) + (8192 * round((value(v("/B<13>" ?result "tran") 7.2e-08) + 0.1))) + (16384 * round((value(v("/B<14>" ?result "tran") 7.2e-08) + 0.1))) + (16384 * round((value(v("/B<15>" ?result "tran") 7.2e-08) + 0.1))) + (16384 * round((value(v("/B<15>" ?result "tran") 7.2e-08) + 0.1))) + round((value(v("/Cin" ?result "tran") 7.2e-08) + 0.1))))
  Output E41 = (((1 * round((value(v("/S<0>" ?result "tran") 7.4e-08) + 0.1))) + (2 * round((value(v("/S<1>" ?result "tran") 7.4e-08) + 0.1))) + (4 * round((value(v("/S<2>" ?result "tran") 7.4e-08) + 0.1))) + (8 * round((value(v("/S<3>" ?result "tran") 7.4e-08) + 0.1))) + (16 * round((value(v("/S<4>" ?result "tran") 7.4e-08) + 0.1))) + (32 * round((value(v("/S<5>" ?result "tran") 7.4e-08) + 0.1))) + (64 * round((value(v("/S<6>" ?result "tran") 7.4e-08) + 0.1))) + (128 * round((value(v("/S<7>" ?result "tran") 7.4e-08) + 0.1))) + (256 * round((value(v("/S<8>" ?result "tran") 7.4e-08) + 0.1))) + (512 * round((value(v("/S<9>" ?result "tran") 7.4e-08) + 0.1))) + (1024 * round((value(v("/S<10>" ?result "tran") 7.4e-08) + 0.1))) + (2048 * round((value(v("/S<11>" ?result "tran") 7.4e-08) + 0.1))) + (4096 * round((value(v("/S<12>" ?result "tran") 7.4e-08) + 0.1))) + (8192 * round((value(v("/S<13>" ?result "tran") 7.4e-08) + 0.1))) + (16384 * round((value(v("/S<14>" ?result "tran") 7.4e-08) + 0.1))) + (16384 * round((value(v("/S<15>" ?result "tran") 7.4e-08) + 0.1))) + (16384 * round((value(v("/S<15>" ?result "tran") 7.4e-08) + 0.1))) + (16384 * round((value(v("/Cout" ?result "tran") 7.4e-08) + 0.1))) + (16384 * round((value(v("/Cout" ?result "tran") 7.4e-08) + 0.1))) + (16384 * round((value(v("/Cout" ?result "tran") 7.4e-08) + 0.1))) + (16384 * round((value(v("/Cout" ?result "tran") 7.4e-08) + 0.1)))) - ((1 * round((value(v("/A<0>" ?result "tran") 7.4e-08) + 0.1))) + (2 * round((value(v("/A<1>" ?result "tran") 7.4e-08) + 0.1))) + (4 * round((value(v("/A<2>" ?result "tran") 7.4e-08) + 0.1))) + (8 * round((value(v("/A<3>" ?result "tran") 7.4e-08) + 0.1))) + (16 * round((value(v("/A<4>" ?result "tran") 7.4e-08) + 0.1))) + (32 * round((value(v("/A<5>" ?result "tran") 7.4e-08) + 0.1))) + (64 * round((value(v("/A<6>" ?result "tran") 7.4e-08) + 0.1))) + (128 * round((value(v("/A<7>" ?result "tran") 7.4e-08) + 0.1))) + (256 * round((value(v("/A<8>" ?result "tran") 7.4e-08) + 0.1))) + (512 * round((value(v("/A<9>" ?result "tran") 7.4e-08) + 0.1))) + (1024 * round((value(v("/A<10>" ?result "tran") 7.4e-08) + 0.1))) + (2048 * round((value(v("/A<11>" ?result "tran") 7.4e-08) + 0.1))) + (4096 * round((value(v("/A<12>" ?result "tran") 7.4e-08) + 0.1))) + (8192 * round((value(v("/A<13>" ?result "tran") 7.4e-08) + 0.1))) + (16384 * round((value(v("/A<14>" ?result "tran") 7.4e-08) + 0.1))) + (16384 * round((value(v("/A<15>" ?result "tran") 7.4e-08) + 0.1))) + (16384 * round((value(v("/A<15>" ?result "tran") 7.4e-08) + 0.1))) + (1 * round((value(v("/B<0>" ?result "tran") 7.4e-08) + 0.1))) + (2 * round((value(v("/B<1>" ?result "tran") 7.4e-08) + 0.1))) + (4 * round((value(v("/B<2>" ?result "tran") 7.4e-08) + 0.1))) + (8 * round((value(v("/B<3>" ?result "tran") 7.4e-08) + 0.1))) + (16 * round((value(v("/B<4>" ?result "tran") 7.4e-08) + 0.1))) + (32 * round((value(v("/B<5>" ?result "tran") 7.4e-08) + 0.1))) + (64 * round((value(v("/B<6>" ?result "tran") 7.4e-08) + 0.1))) + (128 * round((value(v("/B<7>" ?result "tran") 7.4e-08) + 0.1))) + (256 * round((value(v("/B<8>" ?result "tran") 7.4e-08) + 0.1))) + (512 * round((value(v("/B<9>" ?result "tran") 7.4e-08) + 0.1))) + (1024 * round((value(v("/B<10>" ?result "tran") 7.4e-08) + 0.1))) + (2048 * round((value(v("/B<11>" ?result "tran") 7.4e-08) + 0.1))) + (4096 * round((value(v("/B<12>" ?result "tran") 7.4e-08) + 0.1))) + (8192 * round((value(v("/B<13>" ?result "tran") 7.4e-08) + 0.1))) + (16384 * round((value(v("/B<14>" ?result "tran") 7.4e-08) + 0.1))) + (16384 * round((value(v("/B<15>" ?result "tran") 7.4e-08) + 0.1))) + (16384 * round((value(v("/B<15>" ?result "tran") 7.4e-08) + 0.1))) + round((value(v("/Cin" ?result "tran") 7.4e-08) + 0.1))))
  Output E42 = (((1 * round((value(v("/S<0>" ?result "tran") 7.6e-08) + 0.1))) + (2 * round((value(v("/S<1>" ?result "tran") 7.6e-08) + 0.1))) + (4 * round((value(v("/S<2>" ?result "tran") 7.6e-08) + 0.1))) + (8 * round((value(v("/S<3>" ?result "tran") 7.6e-08) + 0.1))) + (16 * round((value(v("/S<4>" ?result "tran") 7.6e-08) + 0.1))) + (32 * round((value(v("/S<5>" ?result "tran") 7.6e-08) + 0.1))) + (64 * round((value(v("/S<6>" ?result "tran") 7.6e-08) + 0.1))) + (128 * round((value(v("/S<7>" ?result "tran") 7.6e-08) + 0.1))) + (256 * round((value(v("/S<8>" ?result "tran") 7.6e-08) + 0.1))) + (512 * round((value(v("/S<9>" ?result "tran") 7.6e-08) + 0.1))) + (1024 * round((value(v("/S<10>" ?result "tran") 7.6e-08) + 0.1))) + (2048 * round((value(v("/S<11>" ?result "tran") 7.6e-08) + 0.1))) + (4096 * round((value(v("/S<12>" ?result "tran") 7.6e-08) + 0.1))) + (8192 * round((value(v("/S<13>" ?result "tran") 7.6e-08) + 0.1))) + (16384 * round((value(v("/S<14>" ?result "tran") 7.6e-08) + 0.1))) + (16384 * round((value(v("/S<15>" ?result "tran") 7.6e-08) + 0.1))) + (16384 * round((value(v("/S<15>" ?result "tran") 7.6e-08) + 0.1))) + (16384 * round((value(v("/Cout" ?result "tran") 7.6e-08) + 0.1))) + (16384 * round((value(v("/Cout" ?result "tran") 7.6e-08) + 0.1))) + (16384 * round((value(v("/Cout" ?result "tran") 7.6e-08) + 0.1))) + (16384 * round((value(v("/Cout" ?result "tran") 7.6e-08) + 0.1)))) - ((1 * round((value(v("/A<0>" ?result "tran") 7.6e-08) + 0.1))) + (2 * round((value(v("/A<1>" ?result "tran") 7.6e-08) + 0.1))) + (4 * round((value(v("/A<2>" ?result "tran") 7.6e-08) + 0.1))) + (8 * round((value(v("/A<3>" ?result "tran") 7.6e-08) + 0.1))) + (16 * round((value(v("/A<4>" ?result "tran") 7.6e-08) + 0.1))) + (32 * round((value(v("/A<5>" ?result "tran") 7.6e-08) + 0.1))) + (64 * round((value(v("/A<6>" ?result "tran") 7.6e-08) + 0.1))) + (128 * round((value(v("/A<7>" ?result "tran") 7.6e-08) + 0.1))) + (256 * round((value(v("/A<8>" ?result "tran") 7.6e-08) + 0.1))) + (512 * round((value(v("/A<9>" ?result "tran") 7.6e-08) + 0.1))) + (1024 * round((value(v("/A<10>" ?result "tran") 7.6e-08) + 0.1))) + (2048 * round((value(v("/A<11>" ?result "tran") 7.6e-08) + 0.1))) + (4096 * round((value(v("/A<12>" ?result "tran") 7.6e-08) + 0.1))) + (8192 * round((value(v("/A<13>" ?result "tran") 7.6e-08) + 0.1))) + (16384 * round((value(v("/A<14>" ?result "tran") 7.6e-08) + 0.1))) + (16384 * round((value(v("/A<15>" ?result "tran") 7.6e-08) + 0.1))) + (16384 * round((value(v("/A<15>" ?result "tran") 7.6e-08) + 0.1))) + (1 * round((value(v("/B<0>" ?result "tran") 7.6e-08) + 0.1))) + (2 * round((value(v("/B<1>" ?result "tran") 7.6e-08) + 0.1))) + (4 * round((value(v("/B<2>" ?result "tran") 7.6e-08) + 0.1))) + (8 * round((value(v("/B<3>" ?result "tran") 7.6e-08) + 0.1))) + (16 * round((value(v("/B<4>" ?result "tran") 7.6e-08) + 0.1))) + (32 * round((value(v("/B<5>" ?result "tran") 7.6e-08) + 0.1))) + (64 * round((value(v("/B<6>" ?result "tran") 7.6e-08) + 0.1))) + (128 * round((value(v("/B<7>" ?result "tran") 7.6e-08) + 0.1))) + (256 * round((value(v("/B<8>" ?result "tran") 7.6e-08) + 0.1))) + (512 * round((value(v("/B<9>" ?result "tran") 7.6e-08) + 0.1))) + (1024 * round((value(v("/B<10>" ?result "tran") 7.6e-08) + 0.1))) + (2048 * round((value(v("/B<11>" ?result "tran") 7.6e-08) + 0.1))) + (4096 * round((value(v("/B<12>" ?result "tran") 7.6e-08) + 0.1))) + (8192 * round((value(v("/B<13>" ?result "tran") 7.6e-08) + 0.1))) + (16384 * round((value(v("/B<14>" ?result "tran") 7.6e-08) + 0.1))) + (16384 * round((value(v("/B<15>" ?result "tran") 7.6e-08) + 0.1))) + (16384 * round((value(v("/B<15>" ?result "tran") 7.6e-08) + 0.1))) + round((value(v("/Cin" ?result "tran") 7.6e-08) + 0.1))))
  Output E43 = (((1 * round((value(v("/S<0>" ?result "tran") 7.8e-08) + 0.1))) + (2 * round((value(v("/S<1>" ?result "tran") 7.8e-08) + 0.1))) + (4 * round((value(v("/S<2>" ?result "tran") 7.8e-08) + 0.1))) + (8 * round((value(v("/S<3>" ?result "tran") 7.8e-08) + 0.1))) + (16 * round((value(v("/S<4>" ?result "tran") 7.8e-08) + 0.1))) + (32 * round((value(v("/S<5>" ?result "tran") 7.8e-08) + 0.1))) + (64 * round((value(v("/S<6>" ?result "tran") 7.8e-08) + 0.1))) + (128 * round((value(v("/S<7>" ?result "tran") 7.8e-08) + 0.1))) + (256 * round((value(v("/S<8>" ?result "tran") 7.8e-08) + 0.1))) + (512 * round((value(v("/S<9>" ?result "tran") 7.8e-08) + 0.1))) + (1024 * round((value(v("/S<10>" ?result "tran") 7.8e-08) + 0.1))) + (2048 * round((value(v("/S<11>" ?result "tran") 7.8e-08) + 0.1))) + (4096 * round((value(v("/S<12>" ?result "tran") 7.8e-08) + 0.1))) + (8192 * round((value(v("/S<13>" ?result "tran") 7.8e-08) + 0.1))) + (16384 * round((value(v("/S<14>" ?result "tran") 7.8e-08) + 0.1))) + (16384 * round((value(v("/S<15>" ?result "tran") 7.8e-08) + 0.1))) + (16384 * round((value(v("/S<15>" ?result "tran") 7.8e-08) + 0.1))) + (16384 * round((value(v("/Cout" ?result "tran") 7.8e-08) + 0.1))) + (16384 * round((value(v("/Cout" ?result "tran") 7.8e-08) + 0.1))) + (16384 * round((value(v("/Cout" ?result "tran") 7.8e-08) + 0.1))) + (16384 * round((value(v("/Cout" ?result "tran") 7.8e-08) + 0.1)))) - ((1 * round((value(v("/A<0>" ?result "tran") 7.8e-08) + 0.1))) + (2 * round((value(v("/A<1>" ?result "tran") 7.8e-08) + 0.1))) + (4 * round((value(v("/A<2>" ?result "tran") 7.8e-08) + 0.1))) + (8 * round((value(v("/A<3>" ?result "tran") 7.8e-08) + 0.1))) + (16 * round((value(v("/A<4>" ?result "tran") 7.8e-08) + 0.1))) + (32 * round((value(v("/A<5>" ?result "tran") 7.8e-08) + 0.1))) + (64 * round((value(v("/A<6>" ?result "tran") 7.8e-08) + 0.1))) + (128 * round((value(v("/A<7>" ?result "tran") 7.8e-08) + 0.1))) + (256 * round((value(v("/A<8>" ?result "tran") 7.8e-08) + 0.1))) + (512 * round((value(v("/A<9>" ?result "tran") 7.8e-08) + 0.1))) + (1024 * round((value(v("/A<10>" ?result "tran") 7.8e-08) + 0.1))) + (2048 * round((value(v("/A<11>" ?result "tran") 7.8e-08) + 0.1))) + (4096 * round((value(v("/A<12>" ?result "tran") 7.8e-08) + 0.1))) + (8192 * round((value(v("/A<13>" ?result "tran") 7.8e-08) + 0.1))) + (16384 * round((value(v("/A<14>" ?result "tran") 7.8e-08) + 0.1))) + (16384 * round((value(v("/A<15>" ?result "tran") 7.8e-08) + 0.1))) + (16384 * round((value(v("/A<15>" ?result "tran") 7.8e-08) + 0.1))) + (1 * round((value(v("/B<0>" ?result "tran") 7.8e-08) + 0.1))) + (2 * round((value(v("/B<1>" ?result "tran") 7.8e-08) + 0.1))) + (4 * round((value(v("/B<2>" ?result "tran") 7.8e-08) + 0.1))) + (8 * round((value(v("/B<3>" ?result "tran") 7.8e-08) + 0.1))) + (16 * round((value(v("/B<4>" ?result "tran") 7.8e-08) + 0.1))) + (32 * round((value(v("/B<5>" ?result "tran") 7.8e-08) + 0.1))) + (64 * round((value(v("/B<6>" ?result "tran") 7.8e-08) + 0.1))) + (128 * round((value(v("/B<7>" ?result "tran") 7.8e-08) + 0.1))) + (256 * round((value(v("/B<8>" ?result "tran") 7.8e-08) + 0.1))) + (512 * round((value(v("/B<9>" ?result "tran") 7.8e-08) + 0.1))) + (1024 * round((value(v("/B<10>" ?result "tran") 7.8e-08) + 0.1))) + (2048 * round((value(v("/B<11>" ?result "tran") 7.8e-08) + 0.1))) + (4096 * round((value(v("/B<12>" ?result "tran") 7.8e-08) + 0.1))) + (8192 * round((value(v("/B<13>" ?result "tran") 7.8e-08) + 0.1))) + (16384 * round((value(v("/B<14>" ?result "tran") 7.8e-08) + 0.1))) + (16384 * round((value(v("/B<15>" ?result "tran") 7.8e-08) + 0.1))) + (16384 * round((value(v("/B<15>" ?result "tran") 7.8e-08) + 0.1))) + round((value(v("/Cin" ?result "tran") 7.8e-08) + 0.1))))
  Output E44 = (((1 * round((value(v("/S<0>" ?result "tran") 8e-08) + 0.1))) + (2 * round((value(v("/S<1>" ?result "tran") 8e-08) + 0.1))) + (4 * round((value(v("/S<2>" ?result "tran") 8e-08) + 0.1))) + (8 * round((value(v("/S<3>" ?result "tran") 8e-08) + 0.1))) + (16 * round((value(v("/S<4>" ?result "tran") 8e-08) + 0.1))) + (32 * round((value(v("/S<5>" ?result "tran") 8e-08) + 0.1))) + (64 * round((value(v("/S<6>" ?result "tran") 8e-08) + 0.1))) + (128 * round((value(v("/S<7>" ?result "tran") 8e-08) + 0.1))) + (256 * round((value(v("/S<8>" ?result "tran") 8e-08) + 0.1))) + (512 * round((value(v("/S<9>" ?result "tran") 8e-08) + 0.1))) + (1024 * round((value(v("/S<10>" ?result "tran") 8e-08) + 0.1))) + (2048 * round((value(v("/S<11>" ?result "tran") 8e-08) + 0.1))) + (4096 * round((value(v("/S<12>" ?result "tran") 8e-08) + 0.1))) + (8192 * round((value(v("/S<13>" ?result "tran") 8e-08) + 0.1))) + (16384 * round((value(v("/S<14>" ?result "tran") 8e-08) + 0.1))) + (16384 * round((value(v("/S<15>" ?result "tran") 8e-08) + 0.1))) + (16384 * round((value(v("/S<15>" ?result "tran") 8e-08) + 0.1))) + (16384 * round((value(v("/Cout" ?result "tran") 8e-08) + 0.1))) + (16384 * round((value(v("/Cout" ?result "tran") 8e-08) + 0.1))) + (16384 * round((value(v("/Cout" ?result "tran") 8e-08) + 0.1))) + (16384 * round((value(v("/Cout" ?result "tran") 8e-08) + 0.1)))) - ((1 * round((value(v("/A<0>" ?result "tran") 8e-08) + 0.1))) + (2 * round((value(v("/A<1>" ?result "tran") 8e-08) + 0.1))) + (4 * round((value(v("/A<2>" ?result "tran") 8e-08) + 0.1))) + (8 * round((value(v("/A<3>" ?result "tran") 8e-08) + 0.1))) + (16 * round((value(v("/A<4>" ?result "tran") 8e-08) + 0.1))) + (32 * round((value(v("/A<5>" ?result "tran") 8e-08) + 0.1))) + (64 * round((value(v("/A<6>" ?result "tran") 8e-08) + 0.1))) + (128 * round((value(v("/A<7>" ?result "tran") 8e-08) + 0.1))) + (256 * round((value(v("/A<8>" ?result "tran") 8e-08) + 0.1))) + (512 * round((value(v("/A<9>" ?result "tran") 8e-08) + 0.1))) + (1024 * round((value(v("/A<10>" ?result "tran") 8e-08) + 0.1))) + (2048 * round((value(v("/A<11>" ?result "tran") 8e-08) + 0.1))) + (4096 * round((value(v("/A<12>" ?result "tran") 8e-08) + 0.1))) + (8192 * round((value(v("/A<13>" ?result "tran") 8e-08) + 0.1))) + (16384 * round((value(v("/A<14>" ?result "tran") 8e-08) + 0.1))) + (16384 * round((value(v("/A<15>" ?result "tran") 8e-08) + 0.1))) + (16384 * round((value(v("/A<15>" ?result "tran") 8e-08) + 0.1))) + (1 * round((value(v("/B<0>" ?result "tran") 8e-08) + 0.1))) + (2 * round((value(v("/B<1>" ?result "tran") 8e-08) + 0.1))) + (4 * round((value(v("/B<2>" ?result "tran") 8e-08) + 0.1))) + (8 * round((value(v("/B<3>" ?result "tran") 8e-08) + 0.1))) + (16 * round((value(v("/B<4>" ?result "tran") 8e-08) + 0.1))) + (32 * round((value(v("/B<5>" ?result "tran") 8e-08) + 0.1))) + (64 * round((value(v("/B<6>" ?result "tran") 8e-08) + 0.1))) + (128 * round((value(v("/B<7>" ?result "tran") 8e-08) + 0.1))) + (256 * round((value(v("/B<8>" ?result "tran") 8e-08) + 0.1))) + (512 * round((value(v("/B<9>" ?result "tran") 8e-08) + 0.1))) + (1024 * round((value(v("/B<10>" ?result "tran") 8e-08) + 0.1))) + (2048 * round((value(v("/B<11>" ?result "tran") 8e-08) + 0.1))) + (4096 * round((value(v("/B<12>" ?result "tran") 8e-08) + 0.1))) + (8192 * round((value(v("/B<13>" ?result "tran") 8e-08) + 0.1))) + (16384 * round((value(v("/B<14>" ?result "tran") 8e-08) + 0.1))) + (16384 * round((value(v("/B<15>" ?result "tran") 8e-08) + 0.1))) + (16384 * round((value(v("/B<15>" ?result "tran") 8e-08) + 0.1))) + round((value(v("/Cin" ?result "tran") 8e-08) + 0.1))))
  Output E45 = (((1 * round((value(v("/S<0>" ?result "tran") 8.2e-08) + 0.1))) + (2 * round((value(v("/S<1>" ?result "tran") 8.2e-08) + 0.1))) + (4 * round((value(v("/S<2>" ?result "tran") 8.2e-08) + 0.1))) + (8 * round((value(v("/S<3>" ?result "tran") 8.2e-08) + 0.1))) + (16 * round((value(v("/S<4>" ?result "tran") 8.2e-08) + 0.1))) + (32 * round((value(v("/S<5>" ?result "tran") 8.2e-08) + 0.1))) + (64 * round((value(v("/S<6>" ?result "tran") 8.2e-08) + 0.1))) + (128 * round((value(v("/S<7>" ?result "tran") 8.2e-08) + 0.1))) + (256 * round((value(v("/S<8>" ?result "tran") 8.2e-08) + 0.1))) + (512 * round((value(v("/S<9>" ?result "tran") 8.2e-08) + 0.1))) + (1024 * round((value(v("/S<10>" ?result "tran") 8.2e-08) + 0.1))) + (2048 * round((value(v("/S<11>" ?result "tran") 8.2e-08) + 0.1))) + (4096 * round((value(v("/S<12>" ?result "tran") 8.2e-08) + 0.1))) + (8192 * round((value(v("/S<13>" ?result "tran") 8.2e-08) + 0.1))) + (16384 * round((value(v("/S<14>" ?result "tran") 8.2e-08) + 0.1))) + (16384 * round((value(v("/S<15>" ?result "tran") 8.2e-08) + 0.1))) + (16384 * round((value(v("/S<15>" ?result "tran") 8.2e-08) + 0.1))) + (16384 * round((value(v("/Cout" ?result "tran") 8.2e-08) + 0.1))) + (16384 * round((value(v("/Cout" ?result "tran") 8.2e-08) + 0.1))) + (16384 * round((value(v("/Cout" ?result "tran") 8.2e-08) + 0.1))) + (16384 * round((value(v("/Cout" ?result "tran") 8.2e-08) + 0.1)))) - ((1 * round((value(v("/A<0>" ?result "tran") 8.2e-08) + 0.1))) + (2 * round((value(v("/A<1>" ?result "tran") 8.2e-08) + 0.1))) + (4 * round((value(v("/A<2>" ?result "tran") 8.2e-08) + 0.1))) + (8 * round((value(v("/A<3>" ?result "tran") 8.2e-08) + 0.1))) + (16 * round((value(v("/A<4>" ?result "tran") 8.2e-08) + 0.1))) + (32 * round((value(v("/A<5>" ?result "tran") 8.2e-08) + 0.1))) + (64 * round((value(v("/A<6>" ?result "tran") 8.2e-08) + 0.1))) + (128 * round((value(v("/A<7>" ?result "tran") 8.2e-08) + 0.1))) + (256 * round((value(v("/A<8>" ?result "tran") 8.2e-08) + 0.1))) + (512 * round((value(v("/A<9>" ?result "tran") 8.2e-08) + 0.1))) + (1024 * round((value(v("/A<10>" ?result "tran") 8.2e-08) + 0.1))) + (2048 * round((value(v("/A<11>" ?result "tran") 8.2e-08) + 0.1))) + (4096 * round((value(v("/A<12>" ?result "tran") 8.2e-08) + 0.1))) + (8192 * round((value(v("/A<13>" ?result "tran") 8.2e-08) + 0.1))) + (16384 * round((value(v("/A<14>" ?result "tran") 8.2e-08) + 0.1))) + (16384 * round((value(v("/A<15>" ?result "tran") 8.2e-08) + 0.1))) + (16384 * round((value(v("/A<15>" ?result "tran") 8.2e-08) + 0.1))) + (1 * round((value(v("/B<0>" ?result "tran") 8.2e-08) + 0.1))) + (2 * round((value(v("/B<1>" ?result "tran") 8.2e-08) + 0.1))) + (4 * round((value(v("/B<2>" ?result "tran") 8.2e-08) + 0.1))) + (8 * round((value(v("/B<3>" ?result "tran") 8.2e-08) + 0.1))) + (16 * round((value(v("/B<4>" ?result "tran") 8.2e-08) + 0.1))) + (32 * round((value(v("/B<5>" ?result "tran") 8.2e-08) + 0.1))) + (64 * round((value(v("/B<6>" ?result "tran") 8.2e-08) + 0.1))) + (128 * round((value(v("/B<7>" ?result "tran") 8.2e-08) + 0.1))) + (256 * round((value(v("/B<8>" ?result "tran") 8.2e-08) + 0.1))) + (512 * round((value(v("/B<9>" ?result "tran") 8.2e-08) + 0.1))) + (1024 * round((value(v("/B<10>" ?result "tran") 8.2e-08) + 0.1))) + (2048 * round((value(v("/B<11>" ?result "tran") 8.2e-08) + 0.1))) + (4096 * round((value(v("/B<12>" ?result "tran") 8.2e-08) + 0.1))) + (8192 * round((value(v("/B<13>" ?result "tran") 8.2e-08) + 0.1))) + (16384 * round((value(v("/B<14>" ?result "tran") 8.2e-08) + 0.1))) + (16384 * round((value(v("/B<15>" ?result "tran") 8.2e-08) + 0.1))) + (16384 * round((value(v("/B<15>" ?result "tran") 8.2e-08) + 0.1))) + round((value(v("/Cin" ?result "tran") 8.2e-08) + 0.1))))
  Output E46 = (((1 * round((value(v("/S<0>" ?result "tran") 8.4e-08) + 0.1))) + (2 * round((value(v("/S<1>" ?result "tran") 8.4e-08) + 0.1))) + (4 * round((value(v("/S<2>" ?result "tran") 8.4e-08) + 0.1))) + (8 * round((value(v("/S<3>" ?result "tran") 8.4e-08) + 0.1))) + (16 * round((value(v("/S<4>" ?result "tran") 8.4e-08) + 0.1))) + (32 * round((value(v("/S<5>" ?result "tran") 8.4e-08) + 0.1))) + (64 * round((value(v("/S<6>" ?result "tran") 8.4e-08) + 0.1))) + (128 * round((value(v("/S<7>" ?result "tran") 8.4e-08) + 0.1))) + (256 * round((value(v("/S<8>" ?result "tran") 8.4e-08) + 0.1))) + (512 * round((value(v("/S<9>" ?result "tran") 8.4e-08) + 0.1))) + (1024 * round((value(v("/S<10>" ?result "tran") 8.4e-08) + 0.1))) + (2048 * round((value(v("/S<11>" ?result "tran") 8.4e-08) + 0.1))) + (4096 * round((value(v("/S<12>" ?result "tran") 8.4e-08) + 0.1))) + (8192 * round((value(v("/S<13>" ?result "tran") 8.4e-08) + 0.1))) + (16384 * round((value(v("/S<14>" ?result "tran") 8.4e-08) + 0.1))) + (16384 * round((value(v("/S<15>" ?result "tran") 8.4e-08) + 0.1))) + (16384 * round((value(v("/S<15>" ?result "tran") 8.4e-08) + 0.1))) + (16384 * round((value(v("/Cout" ?result "tran") 8.4e-08) + 0.1))) + (16384 * round((value(v("/Cout" ?result "tran") 8.4e-08) + 0.1))) + (16384 * round((value(v("/Cout" ?result "tran") 8.4e-08) + 0.1))) + (16384 * round((value(v("/Cout" ?result "tran") 8.4e-08) + 0.1)))) - ((1 * round((value(v("/A<0>" ?result "tran") 8.4e-08) + 0.1))) + (2 * round((value(v("/A<1>" ?result "tran") 8.4e-08) + 0.1))) + (4 * round((value(v("/A<2>" ?result "tran") 8.4e-08) + 0.1))) + (8 * round((value(v("/A<3>" ?result "tran") 8.4e-08) + 0.1))) + (16 * round((value(v("/A<4>" ?result "tran") 8.4e-08) + 0.1))) + (32 * round((value(v("/A<5>" ?result "tran") 8.4e-08) + 0.1))) + (64 * round((value(v("/A<6>" ?result "tran") 8.4e-08) + 0.1))) + (128 * round((value(v("/A<7>" ?result "tran") 8.4e-08) + 0.1))) + (256 * round((value(v("/A<8>" ?result "tran") 8.4e-08) + 0.1))) + (512 * round((value(v("/A<9>" ?result "tran") 8.4e-08) + 0.1))) + (1024 * round((value(v("/A<10>" ?result "tran") 8.4e-08) + 0.1))) + (2048 * round((value(v("/A<11>" ?result "tran") 8.4e-08) + 0.1))) + (4096 * round((value(v("/A<12>" ?result "tran") 8.4e-08) + 0.1))) + (8192 * round((value(v("/A<13>" ?result "tran") 8.4e-08) + 0.1))) + (16384 * round((value(v("/A<14>" ?result "tran") 8.4e-08) + 0.1))) + (16384 * round((value(v("/A<15>" ?result "tran") 8.4e-08) + 0.1))) + (16384 * round((value(v("/A<15>" ?result "tran") 8.4e-08) + 0.1))) + (1 * round((value(v("/B<0>" ?result "tran") 8.4e-08) + 0.1))) + (2 * round((value(v("/B<1>" ?result "tran") 8.4e-08) + 0.1))) + (4 * round((value(v("/B<2>" ?result "tran") 8.4e-08) + 0.1))) + (8 * round((value(v("/B<3>" ?result "tran") 8.4e-08) + 0.1))) + (16 * round((value(v("/B<4>" ?result "tran") 8.4e-08) + 0.1))) + (32 * round((value(v("/B<5>" ?result "tran") 8.4e-08) + 0.1))) + (64 * round((value(v("/B<6>" ?result "tran") 8.4e-08) + 0.1))) + (128 * round((value(v("/B<7>" ?result "tran") 8.4e-08) + 0.1))) + (256 * round((value(v("/B<8>" ?result "tran") 8.4e-08) + 0.1))) + (512 * round((value(v("/B<9>" ?result "tran") 8.4e-08) + 0.1))) + (1024 * round((value(v("/B<10>" ?result "tran") 8.4e-08) + 0.1))) + (2048 * round((value(v("/B<11>" ?result "tran") 8.4e-08) + 0.1))) + (4096 * round((value(v("/B<12>" ?result "tran") 8.4e-08) + 0.1))) + (8192 * round((value(v("/B<13>" ?result "tran") 8.4e-08) + 0.1))) + (16384 * round((value(v("/B<14>" ?result "tran") 8.4e-08) + 0.1))) + (16384 * round((value(v("/B<15>" ?result "tran") 8.4e-08) + 0.1))) + (16384 * round((value(v("/B<15>" ?result "tran") 8.4e-08) + 0.1))) + round((value(v("/Cin" ?result "tran") 8.4e-08) + 0.1))))
  Output E47 = (((1 * round((value(v("/S<0>" ?result "tran") 8.6e-08) + 0.1))) + (2 * round((value(v("/S<1>" ?result "tran") 8.6e-08) + 0.1))) + (4 * round((value(v("/S<2>" ?result "tran") 8.6e-08) + 0.1))) + (8 * round((value(v("/S<3>" ?result "tran") 8.6e-08) + 0.1))) + (16 * round((value(v("/S<4>" ?result "tran") 8.6e-08) + 0.1))) + (32 * round((value(v("/S<5>" ?result "tran") 8.6e-08) + 0.1))) + (64 * round((value(v("/S<6>" ?result "tran") 8.6e-08) + 0.1))) + (128 * round((value(v("/S<7>" ?result "tran") 8.6e-08) + 0.1))) + (256 * round((value(v("/S<8>" ?result "tran") 8.6e-08) + 0.1))) + (512 * round((value(v("/S<9>" ?result "tran") 8.6e-08) + 0.1))) + (1024 * round((value(v("/S<10>" ?result "tran") 8.6e-08) + 0.1))) + (2048 * round((value(v("/S<11>" ?result "tran") 8.6e-08) + 0.1))) + (4096 * round((value(v("/S<12>" ?result "tran") 8.6e-08) + 0.1))) + (8192 * round((value(v("/S<13>" ?result "tran") 8.6e-08) + 0.1))) + (16384 * round((value(v("/S<14>" ?result "tran") 8.6e-08) + 0.1))) + (16384 * round((value(v("/S<15>" ?result "tran") 8.6e-08) + 0.1))) + (16384 * round((value(v("/S<15>" ?result "tran") 8.6e-08) + 0.1))) + (16384 * round((value(v("/Cout" ?result "tran") 8.6e-08) + 0.1))) + (16384 * round((value(v("/Cout" ?result "tran") 8.6e-08) + 0.1))) + (16384 * round((value(v("/Cout" ?result "tran") 8.6e-08) + 0.1))) + (16384 * round((value(v("/Cout" ?result "tran") 8.6e-08) + 0.1)))) - ((1 * round((value(v("/A<0>" ?result "tran") 8.6e-08) + 0.1))) + (2 * round((value(v("/A<1>" ?result "tran") 8.6e-08) + 0.1))) + (4 * round((value(v("/A<2>" ?result "tran") 8.6e-08) + 0.1))) + (8 * round((value(v("/A<3>" ?result "tran") 8.6e-08) + 0.1))) + (16 * round((value(v("/A<4>" ?result "tran") 8.6e-08) + 0.1))) + (32 * round((value(v("/A<5>" ?result "tran") 8.6e-08) + 0.1))) + (64 * round((value(v("/A<6>" ?result "tran") 8.6e-08) + 0.1))) + (128 * round((value(v("/A<7>" ?result "tran") 8.6e-08) + 0.1))) + (256 * round((value(v("/A<8>" ?result "tran") 8.6e-08) + 0.1))) + (512 * round((value(v("/A<9>" ?result "tran") 8.6e-08) + 0.1))) + (1024 * round((value(v("/A<10>" ?result "tran") 8.6e-08) + 0.1))) + (2048 * round((value(v("/A<11>" ?result "tran") 8.6e-08) + 0.1))) + (4096 * round((value(v("/A<12>" ?result "tran") 8.6e-08) + 0.1))) + (8192 * round((value(v("/A<13>" ?result "tran") 8.6e-08) + 0.1))) + (16384 * round((value(v("/A<14>" ?result "tran") 8.6e-08) + 0.1))) + (16384 * round((value(v("/A<15>" ?result "tran") 8.6e-08) + 0.1))) + (16384 * round((value(v("/A<15>" ?result "tran") 8.6e-08) + 0.1))) + (1 * round((value(v("/B<0>" ?result "tran") 8.6e-08) + 0.1))) + (2 * round((value(v("/B<1>" ?result "tran") 8.6e-08) + 0.1))) + (4 * round((value(v("/B<2>" ?result "tran") 8.6e-08) + 0.1))) + (8 * round((value(v("/B<3>" ?result "tran") 8.6e-08) + 0.1))) + (16 * round((value(v("/B<4>" ?result "tran") 8.6e-08) + 0.1))) + (32 * round((value(v("/B<5>" ?result "tran") 8.6e-08) + 0.1))) + (64 * round((value(v("/B<6>" ?result "tran") 8.6e-08) + 0.1))) + (128 * round((value(v("/B<7>" ?result "tran") 8.6e-08) + 0.1))) + (256 * round((value(v("/B<8>" ?result "tran") 8.6e-08) + 0.1))) + (512 * round((value(v("/B<9>" ?result "tran") 8.6e-08) + 0.1))) + (1024 * round((value(v("/B<10>" ?result "tran") 8.6e-08) + 0.1))) + (2048 * round((value(v("/B<11>" ?result "tran") 8.6e-08) + 0.1))) + (4096 * round((value(v("/B<12>" ?result "tran") 8.6e-08) + 0.1))) + (8192 * round((value(v("/B<13>" ?result "tran") 8.6e-08) + 0.1))) + (16384 * round((value(v("/B<14>" ?result "tran") 8.6e-08) + 0.1))) + (16384 * round((value(v("/B<15>" ?result "tran") 8.6e-08) + 0.1))) + (16384 * round((value(v("/B<15>" ?result "tran") 8.6e-08) + 0.1))) + round((value(v("/Cin" ?result "tran") 8.6e-08) + 0.1))))
  Output E48 = (((1 * round((value(v("/S<0>" ?result "tran") 8.8e-08) + 0.1))) + (2 * round((value(v("/S<1>" ?result "tran") 8.8e-08) + 0.1))) + (4 * round((value(v("/S<2>" ?result "tran") 8.8e-08) + 0.1))) + (8 * round((value(v("/S<3>" ?result "tran") 8.8e-08) + 0.1))) + (16 * round((value(v("/S<4>" ?result "tran") 8.8e-08) + 0.1))) + (32 * round((value(v("/S<5>" ?result "tran") 8.8e-08) + 0.1))) + (64 * round((value(v("/S<6>" ?result "tran") 8.8e-08) + 0.1))) + (128 * round((value(v("/S<7>" ?result "tran") 8.8e-08) + 0.1))) + (256 * round((value(v("/S<8>" ?result "tran") 8.8e-08) + 0.1))) + (512 * round((value(v("/S<9>" ?result "tran") 8.8e-08) + 0.1))) + (1024 * round((value(v("/S<10>" ?result "tran") 8.8e-08) + 0.1))) + (2048 * round((value(v("/S<11>" ?result "tran") 8.8e-08) + 0.1))) + (4096 * round((value(v("/S<12>" ?result "tran") 8.8e-08) + 0.1))) + (8192 * round((value(v("/S<13>" ?result "tran") 8.8e-08) + 0.1))) + (16384 * round((value(v("/S<14>" ?result "tran") 8.8e-08) + 0.1))) + (16384 * round((value(v("/S<15>" ?result "tran") 8.8e-08) + 0.1))) + (16384 * round((value(v("/S<15>" ?result "tran") 8.8e-08) + 0.1))) + (16384 * round((value(v("/Cout" ?result "tran") 8.8e-08) + 0.1))) + (16384 * round((value(v("/Cout" ?result "tran") 8.8e-08) + 0.1))) + (16384 * round((value(v("/Cout" ?result "tran") 8.8e-08) + 0.1))) + (16384 * round((value(v("/Cout" ?result "tran") 8.8e-08) + 0.1)))) - ((1 * round((value(v("/A<0>" ?result "tran") 8.8e-08) + 0.1))) + (2 * round((value(v("/A<1>" ?result "tran") 8.8e-08) + 0.1))) + (4 * round((value(v("/A<2>" ?result "tran") 8.8e-08) + 0.1))) + (8 * round((value(v("/A<3>" ?result "tran") 8.8e-08) + 0.1))) + (16 * round((value(v("/A<4>" ?result "tran") 8.8e-08) + 0.1))) + (32 * round((value(v("/A<5>" ?result "tran") 8.8e-08) + 0.1))) + (64 * round((value(v("/A<6>" ?result "tran") 8.8e-08) + 0.1))) + (128 * round((value(v("/A<7>" ?result "tran") 8.8e-08) + 0.1))) + (256 * round((value(v("/A<8>" ?result "tran") 8.8e-08) + 0.1))) + (512 * round((value(v("/A<9>" ?result "tran") 8.8e-08) + 0.1))) + (1024 * round((value(v("/A<10>" ?result "tran") 8.8e-08) + 0.1))) + (2048 * round((value(v("/A<11>" ?result "tran") 8.8e-08) + 0.1))) + (4096 * round((value(v("/A<12>" ?result "tran") 8.8e-08) + 0.1))) + (8192 * round((value(v("/A<13>" ?result "tran") 8.8e-08) + 0.1))) + (16384 * round((value(v("/A<14>" ?result "tran") 8.8e-08) + 0.1))) + (16384 * round((value(v("/A<15>" ?result "tran") 8.8e-08) + 0.1))) + (16384 * round((value(v("/A<15>" ?result "tran") 8.8e-08) + 0.1))) + (1 * round((value(v("/B<0>" ?result "tran") 8.8e-08) + 0.1))) + (2 * round((value(v("/B<1>" ?result "tran") 8.8e-08) + 0.1))) + (4 * round((value(v("/B<2>" ?result "tran") 8.8e-08) + 0.1))) + (8 * round((value(v("/B<3>" ?result "tran") 8.8e-08) + 0.1))) + (16 * round((value(v("/B<4>" ?result "tran") 8.8e-08) + 0.1))) + (32 * round((value(v("/B<5>" ?result "tran") 8.8e-08) + 0.1))) + (64 * round((value(v("/B<6>" ?result "tran") 8.8e-08) + 0.1))) + (128 * round((value(v("/B<7>" ?result "tran") 8.8e-08) + 0.1))) + (256 * round((value(v("/B<8>" ?result "tran") 8.8e-08) + 0.1))) + (512 * round((value(v("/B<9>" ?result "tran") 8.8e-08) + 0.1))) + (1024 * round((value(v("/B<10>" ?result "tran") 8.8e-08) + 0.1))) + (2048 * round((value(v("/B<11>" ?result "tran") 8.8e-08) + 0.1))) + (4096 * round((value(v("/B<12>" ?result "tran") 8.8e-08) + 0.1))) + (8192 * round((value(v("/B<13>" ?result "tran") 8.8e-08) + 0.1))) + (16384 * round((value(v("/B<14>" ?result "tran") 8.8e-08) + 0.1))) + (16384 * round((value(v("/B<15>" ?result "tran") 8.8e-08) + 0.1))) + (16384 * round((value(v("/B<15>" ?result "tran") 8.8e-08) + 0.1))) + round((value(v("/Cin" ?result "tran") 8.8e-08) + 0.1))))
  Output E49 = (((1 * round((value(v("/S<0>" ?result "tran") 9e-08) + 0.1))) + (2 * round((value(v("/S<1>" ?result "tran") 9e-08) + 0.1))) + (4 * round((value(v("/S<2>" ?result "tran") 9e-08) + 0.1))) + (8 * round((value(v("/S<3>" ?result "tran") 9e-08) + 0.1))) + (16 * round((value(v("/S<4>" ?result "tran") 9e-08) + 0.1))) + (32 * round((value(v("/S<5>" ?result "tran") 9e-08) + 0.1))) + (64 * round((value(v("/S<6>" ?result "tran") 9e-08) + 0.1))) + (128 * round((value(v("/S<7>" ?result "tran") 9e-08) + 0.1))) + (256 * round((value(v("/S<8>" ?result "tran") 9e-08) + 0.1))) + (512 * round((value(v("/S<9>" ?result "tran") 9e-08) + 0.1))) + (1024 * round((value(v("/S<10>" ?result "tran") 9e-08) + 0.1))) + (2048 * round((value(v("/S<11>" ?result "tran") 9e-08) + 0.1))) + (4096 * round((value(v("/S<12>" ?result "tran") 9e-08) + 0.1))) + (8192 * round((value(v("/S<13>" ?result "tran") 9e-08) + 0.1))) + (16384 * round((value(v("/S<14>" ?result "tran") 9e-08) + 0.1))) + (16384 * round((value(v("/S<15>" ?result "tran") 9e-08) + 0.1))) + (16384 * round((value(v("/S<15>" ?result "tran") 9e-08) + 0.1))) + (16384 * round((value(v("/Cout" ?result "tran") 9e-08) + 0.1))) + (16384 * round((value(v("/Cout" ?result "tran") 9e-08) + 0.1))) + (16384 * round((value(v("/Cout" ?result "tran") 9e-08) + 0.1))) + (16384 * round((value(v("/Cout" ?result "tran") 9e-08) + 0.1)))) - ((1 * round((value(v("/A<0>" ?result "tran") 9e-08) + 0.1))) + (2 * round((value(v("/A<1>" ?result "tran") 9e-08) + 0.1))) + (4 * round((value(v("/A<2>" ?result "tran") 9e-08) + 0.1))) + (8 * round((value(v("/A<3>" ?result "tran") 9e-08) + 0.1))) + (16 * round((value(v("/A<4>" ?result "tran") 9e-08) + 0.1))) + (32 * round((value(v("/A<5>" ?result "tran") 9e-08) + 0.1))) + (64 * round((value(v("/A<6>" ?result "tran") 9e-08) + 0.1))) + (128 * round((value(v("/A<7>" ?result "tran") 9e-08) + 0.1))) + (256 * round((value(v("/A<8>" ?result "tran") 9e-08) + 0.1))) + (512 * round((value(v("/A<9>" ?result "tran") 9e-08) + 0.1))) + (1024 * round((value(v("/A<10>" ?result "tran") 9e-08) + 0.1))) + (2048 * round((value(v("/A<11>" ?result "tran") 9e-08) + 0.1))) + (4096 * round((value(v("/A<12>" ?result "tran") 9e-08) + 0.1))) + (8192 * round((value(v("/A<13>" ?result "tran") 9e-08) + 0.1))) + (16384 * round((value(v("/A<14>" ?result "tran") 9e-08) + 0.1))) + (16384 * round((value(v("/A<15>" ?result "tran") 9e-08) + 0.1))) + (16384 * round((value(v("/A<15>" ?result "tran") 9e-08) + 0.1))) + (1 * round((value(v("/B<0>" ?result "tran") 9e-08) + 0.1))) + (2 * round((value(v("/B<1>" ?result "tran") 9e-08) + 0.1))) + (4 * round((value(v("/B<2>" ?result "tran") 9e-08) + 0.1))) + (8 * round((value(v("/B<3>" ?result "tran") 9e-08) + 0.1))) + (16 * round((value(v("/B<4>" ?result "tran") 9e-08) + 0.1))) + (32 * round((value(v("/B<5>" ?result "tran") 9e-08) + 0.1))) + (64 * round((value(v("/B<6>" ?result "tran") 9e-08) + 0.1))) + (128 * round((value(v("/B<7>" ?result "tran") 9e-08) + 0.1))) + (256 * round((value(v("/B<8>" ?result "tran") 9e-08) + 0.1))) + (512 * round((value(v("/B<9>" ?result "tran") 9e-08) + 0.1))) + (1024 * round((value(v("/B<10>" ?result "tran") 9e-08) + 0.1))) + (2048 * round((value(v("/B<11>" ?result "tran") 9e-08) + 0.1))) + (4096 * round((value(v("/B<12>" ?result "tran") 9e-08) + 0.1))) + (8192 * round((value(v("/B<13>" ?result "tran") 9e-08) + 0.1))) + (16384 * round((value(v("/B<14>" ?result "tran") 9e-08) + 0.1))) + (16384 * round((value(v("/B<15>" ?result "tran") 9e-08) + 0.1))) + (16384 * round((value(v("/B<15>" ?result "tran") 9e-08) + 0.1))) + round((value(v("/Cin" ?result "tran") 9e-08) + 0.1))))
  Output Power = abs(abs(abs(average((IT("/I0/VDD") * VT("/net2"))))))
  Signals: /A<15:0>, /B<15:0>, /S<15:0>, /Cout, /Cin, /I0/VDD (terminal), /net2
Run mode: Single Run, Sweeps and Corners
