ADE simulation setup
Test project_ADDER_TEST_1: project/ADDER_TEST/schematic, simulator spectre
  Models: /home/dicd26/dicd25039/hspice_nom.include
  Temperature: 27
  Analysis tran: stop=90n errpreset=conservative
  Signals: /A<15:0>, /B<15:0>, /net1, /net5, /S<15:0>
Run mode: Single Run, Sweeps and Corners
