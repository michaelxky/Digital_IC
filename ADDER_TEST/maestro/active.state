ADE simulation setup
Test project_ADDER_TEST_1: project/ADDER_TEST/schematic, simulator spectre
  Models: /home/dicd26/dicd25088/hspice_nom.include
  Temperature: 27
  Analysis tran: stop=90n errpreset=conservative
  Signals: /A<15:0>, /B<15:0>, /S<15:0>, /I0/G8_0, /I0/G7_0_B, /I0/G7_4, /I0/G1_0, /I0/G2_0, /I0/G12_8
Run mode: Single Run, Sweeps and Corners
