ADE simulation setup
Run mode: Single Run, Sweeps and Corners
Tests:
  project_ADDER_TEST_1: project/ADDER_TEST/schematic, simulator spectre
    Outputs: RiseS; RiseC; FallS; FallC; 1; LogicCheck; MeanSRise; MeanSFall; max(list(riseTime(v("/S<0>" ?result "tran") 0 nil 1 nil 10 90) riseTime(v("/S<1>" ?result "tran") 0 nil 1 nil 10 90) riseTime(v("/S<2>" ?result "tran") 0 nil 1 nil 10 90) riseTime(v("/S<3>" ?result "tran") 0 nil 1 nil 10 90) riseTime(v("/S<4>" ?result "tran") 0 nil 1 nil 10 90) riseTime(v("/S<5>" ?result "tran") 0 nil 1 nil 10 90) riseTime(v("/S<6>" ?result "tran") 0 nil 1 nil 10 90) riseTime(v("/S<7>" ?result "tran") 0 nil 1 nil 10 90) riseTime(v("/S<8>" ?result "tran") 0 nil 1 nil 10 90) riseTime(v("/S<9>" ?result "tran") 0 nil 1 nil 10 90) riseTime(v("/S<10>" ?result "tran") 0 nil 1 nil 10 90) riseTime(v("/S<11>" ?result "tran") 0 nil 1 nil 10 90) riseTime(v("/S<12>" ?result "tran") 0 nil 1 nil 10 90) riseTime(v("/S<13>" ?result "tran") 0 nil 1 nil 10 90) riseTime(v("/S<14>" ?result "tran") 0 nil 1 nil 10 90) riseTime(v("/S<15>" ?result "tran") 0 nil 1 nil 10 90))); MaxRsieS; MaxFallS
