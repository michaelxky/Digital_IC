ADE simulation setup
Run mode: Single Run, Sweeps and Corners
Tests:
  project_ADDER_TEST_1: project/ADDER_TEST/schematic, simulator spectre
    Outputs: /S<8>; /S<9>
