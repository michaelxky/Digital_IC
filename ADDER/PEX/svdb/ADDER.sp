* SPICE NETLIST
***************************************

.SUBCKT BLACK GND VDD Pi Ph Pout Gi Gh Gout
** N=13 EP=8 IP=0 FDC=14
M0 12 Pi GND GND NMOS_VTG L=5e-08 W=9e-08 AD=1.305e-14 AS=9.45e-15 PD=4.7e-07 PS=3.9e-07 $X=360 $Y=855 $D=5
M1 4 Ph 12 GND NMOS_VTG L=5e-08 W=9e-08 AD=9.45e-15 AS=1.305e-14 PD=3.9e-07 PS=4.7e-07 $X=750 $Y=855 $D=5
M2 Pout 4 GND GND NMOS_VTG L=5e-08 W=9e-08 AD=9.45e-15 AS=9.45e-15 PD=3.9e-07 PS=3.9e-07 $X=1510 $Y=855 $D=5
M3 13 Ph GND GND NMOS_VTG L=5e-08 W=9e-08 AD=1.7775e-14 AS=1.1475e-14 PD=5.75e-07 PS=4.35e-07 $X=2320 $Y=855 $D=5
M4 11 Gi 13 GND NMOS_VTG L=5e-08 W=9e-08 AD=2.3175e-14 AS=1.7775e-14 PD=6.95e-07 PS=5.75e-07 $X=2815 $Y=855 $D=5
M5 GND Gh 11 GND NMOS_VTG L=5e-08 W=9e-08 AD=1.575e-14 AS=2.3175e-14 PD=5.3e-07 PS=6.95e-07 $X=3430 $Y=855 $D=5
M6 Gout 11 GND GND NMOS_VTG L=5e-08 W=9e-08 AD=9.45e-15 AS=9.45e-15 PD=3.9e-07 PS=3.9e-07 $X=4290 $Y=855 $D=5
M7 4 Pi VDD VDD PMOS_VTG L=5e-08 W=1.8e-07 AD=2.61e-14 AS=1.89e-14 PD=6.5e-07 PS=5.7e-07 $X=360 $Y=1835 $D=4
M8 VDD Ph 4 VDD PMOS_VTG L=5e-08 W=1.8e-07 AD=1.89e-14 AS=2.61e-14 PD=5.7e-07 PS=6.5e-07 $X=750 $Y=1835 $D=4
M9 Pout 4 VDD VDD PMOS_VTG L=5e-08 W=1.8e-07 AD=1.89e-14 AS=1.89e-14 PD=5.7e-07 PS=5.7e-07 $X=1510 $Y=1835 $D=4
M10 VDD Ph 10 VDD PMOS_VTG L=5e-08 W=1.8e-07 AD=3.555e-14 AS=2.25e-14 PD=7.55e-07 PS=6.1e-07 $X=2320 $Y=1835 $D=4
M11 10 Gi VDD VDD PMOS_VTG L=5e-08 W=1.8e-07 AD=4.635e-14 AS=3.555e-14 PD=8.75e-07 PS=7.55e-07 $X=2815 $Y=1835 $D=4
M12 11 Gh 10 VDD PMOS_VTG L=5e-08 W=1.8e-07 AD=3.06e-14 AS=4.635e-14 PD=7e-07 PS=8.75e-07 $X=3430 $Y=1835 $D=4
M13 Gout 11 VDD VDD PMOS_VTG L=5e-08 W=1.8e-07 AD=1.89e-14 AS=1.89e-14 PD=5.7e-07 PS=5.7e-07 $X=4290 $Y=1835 $D=4
.ENDS
***************************************
.SUBCKT DBUFFER GND VDD IN OUT
** N=5 EP=4 IP=0 FDC=16
M0 5 IN GND GND NMOS_VTG L=5e-08 W=1.8e-07 AD=2.52e-14 AS=2.07e-14 PD=6.4e-07 PS=5.9e-07 $X=2045 $Y=1030 $D=5
M1 GND IN 5 GND NMOS_VTG L=5e-08 W=1.8e-07 AD=3.465e-14 AS=2.52e-14 PD=7.45e-07 PS=6.4e-07 $X=2425 $Y=1030 $D=5
M2 OUT 5 GND GND NMOS_VTG L=5e-08 W=1.8e-07 AD=2.52e-14 AS=3.465e-14 PD=6.4e-07 PS=7.45e-07 $X=2910 $Y=1030 $D=5
M3 GND 5 OUT GND NMOS_VTG L=5e-08 W=1.8e-07 AD=2.7e-14 AS=2.52e-14 PD=6.6e-07 PS=6.4e-07 $X=3290 $Y=1030 $D=5
M4 OUT 5 GND GND NMOS_VTG L=5e-08 W=1.8e-07 AD=2.52e-14 AS=2.7e-14 PD=6.4e-07 PS=6.6e-07 $X=3690 $Y=1030 $D=5
M5 GND 5 OUT GND NMOS_VTG L=5e-08 W=1.8e-07 AD=2.88e-14 AS=2.52e-14 PD=6.8e-07 PS=6.4e-07 $X=4070 $Y=1030 $D=5
M6 OUT 5 GND GND NMOS_VTG L=5e-08 W=1.8e-07 AD=2.52e-14 AS=2.88e-14 PD=6.4e-07 PS=6.8e-07 $X=4490 $Y=1030 $D=5
M7 GND 5 OUT GND NMOS_VTG L=5e-08 W=1.8e-07 AD=1.89e-14 AS=2.52e-14 PD=5.7e-07 PS=6.4e-07 $X=4870 $Y=1030 $D=5
M8 5 IN VDD VDD PMOS_VTG L=5e-08 W=3e-07 AD=4.2e-14 AS=3.45e-14 PD=8.8e-07 PS=8.3e-07 $X=2045 $Y=1820 $D=4
M9 VDD IN 5 VDD PMOS_VTG L=5e-08 W=3e-07 AD=5.775e-14 AS=4.2e-14 PD=9.85e-07 PS=8.8e-07 $X=2425 $Y=1820 $D=4
M10 OUT 5 VDD VDD PMOS_VTG L=5e-08 W=3e-07 AD=4.2e-14 AS=5.775e-14 PD=8.8e-07 PS=9.85e-07 $X=2910 $Y=1820 $D=4
M11 VDD 5 OUT VDD PMOS_VTG L=5e-08 W=3e-07 AD=4.5e-14 AS=4.2e-14 PD=9e-07 PS=8.8e-07 $X=3290 $Y=1820 $D=4
M12 OUT 5 VDD VDD PMOS_VTG L=5e-08 W=3e-07 AD=4.2e-14 AS=4.5e-14 PD=8.8e-07 PS=9e-07 $X=3690 $Y=1820 $D=4
M13 VDD 5 OUT VDD PMOS_VTG L=5e-08 W=3e-07 AD=4.8e-14 AS=4.2e-14 PD=9.2e-07 PS=8.8e-07 $X=4070 $Y=1820 $D=4
M14 OUT 5 VDD VDD PMOS_VTG L=5e-08 W=3e-07 AD=4.2e-14 AS=4.8e-14 PD=8.8e-07 PS=9.2e-07 $X=4490 $Y=1820 $D=4
M15 VDD 5 OUT VDD PMOS_VTG L=5e-08 W=3e-07 AD=3.15e-14 AS=4.2e-14 PD=8.1e-07 PS=8.8e-07 $X=4870 $Y=1820 $D=4
.ENDS
***************************************
.SUBCKT M3_M2_CDNS_774714328837
** N=1 EP=0 IP=0 FDC=0
.ENDS
***************************************
.SUBCKT GREYCELLHP Ph GND VDD Gi Gh GG
** N=9 EP=6 IP=0 FDC=8
M0 9 Ph GND GND NMOS_VTG L=5e-08 W=9e-08 AD=1.7775e-14 AS=1.08e-14 PD=5.75e-07 PS=4.2e-07 $X=420 $Y=565 $D=5
M1 8 Gi 9 GND NMOS_VTG L=5e-08 W=9e-08 AD=2.3175e-14 AS=1.7775e-14 PD=6.95e-07 PS=5.75e-07 $X=915 $Y=565 $D=5
M2 GND Gh 8 GND NMOS_VTG L=5e-08 W=9e-08 AD=9.9e-15 AS=2.3175e-14 PD=4e-07 PS=6.95e-07 $X=1530 $Y=565 $D=5
M3 GG 8 GND GND NMOS_VTG L=5e-08 W=9e-08 AD=9.45e-15 AS=9.45e-15 PD=3.9e-07 PS=3.9e-07 $X=2285 $Y=565 $D=5
M4 VDD Ph 7 VDD PMOS_VTG L=5e-08 W=1.8e-07 AD=3.555e-14 AS=2.16e-14 PD=7.55e-07 PS=6e-07 $X=420 $Y=1545 $D=4
M5 7 Gi VDD VDD PMOS_VTG L=5e-08 W=1.8e-07 AD=4.635e-14 AS=3.555e-14 PD=8.75e-07 PS=7.55e-07 $X=915 $Y=1545 $D=4
M6 8 Gh 7 VDD PMOS_VTG L=5e-08 W=1.8e-07 AD=2.565e-14 AS=4.635e-14 PD=6.45e-07 PS=8.75e-07 $X=1530 $Y=1545 $D=4
M7 GG 8 VDD VDD PMOS_VTG L=5e-08 W=1.8e-07 AD=1.89e-14 AS=1.89e-14 PD=5.7e-07 PS=5.7e-07 $X=2285 $Y=1545 $D=4
.ENDS
***************************************
.SUBCKT GP B A GND VDD G P
** N=10 EP=6 IP=0 FDC=14
M0 10 B GND GND NMOS_VTG L=5e-08 W=9e-08 AD=1.305e-14 AS=9.45e-15 PD=4.7e-07 PS=3.9e-07 $X=955 $Y=1365 $D=5
M1 2 A 10 GND NMOS_VTG L=5e-08 W=9e-08 AD=9.45e-15 AS=1.305e-14 PD=3.9e-07 PS=4.7e-07 $X=1345 $Y=1365 $D=5
M2 G 2 GND GND NMOS_VTG L=5e-08 W=9e-08 AD=9.45e-15 AS=9.45e-15 PD=3.9e-07 PS=3.9e-07 $X=2105 $Y=1365 $D=5
M3 9 B GND GND NMOS_VTG L=5e-08 W=9e-08 AD=9.45e-15 AS=9.45e-15 PD=3.9e-07 PS=3.9e-07 $X=2925 $Y=1365 $D=5
M4 7 A B GND NMOS_VTG L=5e-08 W=9e-08 AD=1.26e-14 AS=9.45e-15 PD=4.6e-07 PS=3.9e-07 $X=3690 $Y=1365 $D=5
M5 A B 7 GND NMOS_VTG L=5e-08 W=9e-08 AD=9.45e-15 AS=1.26e-14 PD=3.9e-07 PS=4.6e-07 $X=4070 $Y=1365 $D=5
M6 P 7 GND GND NMOS_VTG L=5e-08 W=9e-08 AD=9.45e-15 AS=9.45e-15 PD=3.9e-07 PS=3.9e-07 $X=4825 $Y=1365 $D=5
M7 2 B VDD VDD PMOS_VTG L=5e-08 W=1.8e-07 AD=2.61e-14 AS=1.89e-14 PD=6.5e-07 PS=5.7e-07 $X=955 $Y=2345 $D=4
M8 VDD A 2 VDD PMOS_VTG L=5e-08 W=1.8e-07 AD=1.89e-14 AS=2.61e-14 PD=5.7e-07 PS=6.5e-07 $X=1345 $Y=2345 $D=4
M9 G 2 VDD VDD PMOS_VTG L=5e-08 W=1.8e-07 AD=1.89e-14 AS=1.89e-14 PD=5.7e-07 PS=5.7e-07 $X=2105 $Y=2345 $D=4
M10 9 B VDD VDD PMOS_VTG L=5e-08 W=1.8e-07 AD=1.89e-14 AS=1.89e-14 PD=5.7e-07 PS=5.7e-07 $X=2925 $Y=2345 $D=4
M11 7 A 9 VDD PMOS_VTG L=5e-08 W=1.8e-07 AD=2.52e-14 AS=1.89e-14 PD=6.4e-07 PS=5.7e-07 $X=3690 $Y=2345 $D=4
M12 A 9 7 VDD PMOS_VTG L=5e-08 W=1.8e-07 AD=1.89e-14 AS=2.52e-14 PD=5.7e-07 PS=6.4e-07 $X=4070 $Y=2345 $D=4
M13 P 7 VDD VDD PMOS_VTG L=5e-08 W=1.8e-07 AD=1.89e-14 AS=1.89e-14 PD=5.7e-07 PS=5.7e-07 $X=4825 $Y=2345 $D=4
.ENDS
***************************************
.SUBCKT ICV_1 1 2 3 4 5 6 7 8 9 10
*.CALIBRE ICV_CELL 9
** N=10 EP=10 IP=12 FDC=28
X0 1 2 5 6 7 8 GP $T=0 0 0 0 $X=595 $Y=845
X1 3 4 5 6 9 10 GP $T=4750 0 0 0 $X=5345 $Y=845
.ENDS
***************************************
.SUBCKT XOR B GND VDD A Y
** N=7 EP=5 IP=0 FDC=8
M0 6 B GND GND NMOS_VTG L=5e-08 W=9e-08 AD=9.45e-15 AS=9.45e-15 PD=3.9e-07 PS=3.9e-07 $X=580 $Y=735 $D=5
M1 5 A B GND NMOS_VTG L=5e-08 W=9e-08 AD=1.26e-14 AS=9.45e-15 PD=4.6e-07 PS=3.9e-07 $X=1345 $Y=735 $D=5
M2 A B 5 GND NMOS_VTG L=5e-08 W=9e-08 AD=9.45e-15 AS=1.26e-14 PD=3.9e-07 PS=4.6e-07 $X=1725 $Y=735 $D=5
M3 Y 5 GND GND NMOS_VTG L=5e-08 W=9e-08 AD=9.45e-15 AS=9.45e-15 PD=3.9e-07 PS=3.9e-07 $X=2480 $Y=735 $D=5
M4 6 B VDD VDD PMOS_VTG L=5e-08 W=1.8e-07 AD=1.89e-14 AS=1.89e-14 PD=5.7e-07 PS=5.7e-07 $X=580 $Y=1715 $D=4
M5 5 A 6 VDD PMOS_VTG L=5e-08 W=1.8e-07 AD=2.52e-14 AS=1.89e-14 PD=6.4e-07 PS=5.7e-07 $X=1345 $Y=1715 $D=4
M6 A 6 5 VDD PMOS_VTG L=5e-08 W=1.8e-07 AD=1.89e-14 AS=2.52e-14 PD=5.7e-07 PS=6.4e-07 $X=1725 $Y=1715 $D=4
M7 Y 5 VDD VDD PMOS_VTG L=5e-08 W=1.8e-07 AD=1.89e-14 AS=1.89e-14 PD=5.7e-07 PS=5.7e-07 $X=2480 $Y=1715 $D=4
.ENDS
***************************************
.SUBCKT ICV_2 1 2 3 4 5 6 7 8
*.CALIBRE ICV_CELL 9
** N=8 EP=8 IP=10 FDC=16
X0 6 3 4 5 1 XOR $T=0 0 0 0 $X=-1850 $Y=145
X1 8 3 4 7 2 XOR $T=4750 0 0 0 $X=2900 $Y=145
.ENDS
***************************************
.SUBCKT ICV_3 1 2 3 4 5 6 7 8 9 10 11 12 13 14
*.CALIBRE ICV_CELL 9
** N=14 EP=14 IP=16 FDC=28
X0 2 1 3 4 5 9 10 11 BLACK $T=0 0 0 0 $X=0 $Y=340
X1 2 1 6 7 8 12 13 14 BLACK $T=4750 0 0 0 $X=4750 $Y=340
.ENDS
***************************************
.SUBCKT ICV_4 1 2 3 4 5 6
*.CALIBRE ICV_CELL 9
** N=6 EP=6 IP=8 FDC=32
X0 1 2 5 3 DBUFFER $T=-4750 0 0 0 $X=-3055 $Y=530
X1 1 2 6 4 DBUFFER $T=0 0 0 0 $X=1695 $Y=530
.ENDS
***************************************
.SUBCKT ICV_5 1 2 3 4 5 6 7 8 9 10
*.CALIBRE ICV_CELL 9
** N=10 EP=10 IP=12 FDC=16
X0 5 3 4 1 6 7 GREYCELLHP $T=0 0 0 0 $X=0 $Y=50
X1 8 3 4 2 9 10 GREYCELLHP $T=4750 0 0 0 $X=4750 $Y=50
.ENDS
***************************************
.SUBCKT ADDER B<0> A<0> Cin S<0> B<1> A<1> S<1> B<2> A<2> S<2> B<3> A<3> S<3> B<4> A<4> S<4> GND B<5> A<5> S<5>
+ VDD B<6> A<6> S<6> B<7> A<7> S<7> B<8> A<8> S<8> B<9> A<9> S<9> B<10> A<10> S<10> B<11> A<11> S<11> B<12>
+ A<12> S<12> B<13> A<13> S<13> B<14> A<14> S<14> B<15> A<15> S<15> Cout
** N=150 EP=52 IP=411 FDC=990
X0 GND VDD 77 85 74 80 140 75 BLACK $T=12170 15910 0 0 $X=12170 $Y=16250
X1 GND VDD 130 133 132 149 150 134 BLACK $T=69170 15910 0 0 $X=69170 $Y=16250
X2 GND VDD 105 139 122 107 138 124 BLACK $T=77670 8110 0 0 $X=77670 $Y=8450
X3 GND VDD 15 S<14> DBUFFER $T=75615 3070 1 180 $X=69170 $Y=3600
X4 GND VDD 16 S<15> DBUFFER $T=79365 3070 1 180 $X=72920 $Y=3600
X5 GND VDD 137 Cout DBUFFER $T=75975 3070 0 0 $X=77670 $Y=3600
X15 90 GND VDD 69 89 91 GREYCELLHP $T=16920 16200 0 0 $X=16920 $Y=16250
X16 135 GND VDD 70 136 137 GREYCELLHP $T=73920 16200 0 0 $X=73920 $Y=16250
X17 B<0> A<0> B<1> A<1> GND VDD 76 73 80 77 ICV_1 $T=2075 21840 1 0 $X=2670 $Y=18635
X18 B<2> A<2> B<3> A<3> GND VDD 140 85 89 90 ICV_1 $T=11575 21840 1 0 $X=12170 $Y=18635
X19 B<4> A<4> B<5> A<5> GND VDD 141 94 142 98 ICV_1 $T=21075 21840 1 0 $X=21670 $Y=18635
X20 B<6> A<6> B<7> A<7> GND VDD 143 102 93 92 ICV_1 $T=30575 21840 1 0 $X=31170 $Y=18635
X21 B<8> A<8> B<9> A<9> GND VDD 144 111 145 115 ICV_1 $T=40075 21840 1 0 $X=40670 $Y=18635
X22 B<10> A<10> B<11> A<11> GND VDD 146 119 147 125 ICV_1 $T=49575 21840 1 0 $X=50170 $Y=18635
X23 B<12> A<12> B<13> A<13> GND VDD 148 127 149 130 ICV_1 $T=59075 21840 1 0 $X=59670 $Y=18635
X24 B<14> A<14> B<15> A<15> GND VDD 150 133 136 135 ICV_1 $T=68575 21840 1 0 $X=69170 $Y=18635
X25 1 2 GND VDD Cin 73 71 77 ICV_2 $T=4520 8595 1 0 $X=2670 $Y=5990
X26 3 4 GND VDD 82 85 69 90 ICV_2 $T=14020 8595 1 0 $X=12170 $Y=5990
X27 5 6 GND VDD 91 94 81 98 ICV_2 $T=23520 8595 1 0 $X=21670 $Y=5990
X28 7 8 GND VDD 86 102 72 92 ICV_2 $T=33020 8595 1 0 $X=31170 $Y=5990
X29 9 10 GND VDD 95 111 99 115 ICV_2 $T=42520 8595 1 0 $X=40670 $Y=5990
X30 11 12 GND VDD 103 119 108 125 ICV_2 $T=52020 8595 1 0 $X=50170 $Y=5990
X31 13 14 GND VDD 112 127 116 130 ICV_2 $T=61520 8595 1 0 $X=59670 $Y=5990
X32 15 16 GND VDD 120 133 70 135 ICV_2 $T=71020 8595 1 0 $X=69170 $Y=5990
X33 VDD GND 90 94 78 78 98 83 89 141 79 79 142 84 ICV_3 $T=21670 15910 0 0 $X=21670 $Y=16250
X34 VDD GND 98 102 106 78 106 87 142 143 104 79 104 88 ICV_3 $T=31170 15910 0 0 $X=31170 $Y=16250
X35 VDD GND 92 111 96 96 115 100 93 144 97 97 145 101 ICV_3 $T=40670 15910 0 0 $X=40670 $Y=16250
X36 VDD GND 115 119 123 96 123 105 145 146 121 97 121 107 ICV_3 $T=50170 15910 0 0 $X=50170 $Y=16250
X37 VDD GND 105 125 109 105 126 113 107 147 110 107 128 114 ICV_3 $T=58670 8110 0 0 $X=58670 $Y=8450
X38 VDD GND 125 127 126 126 130 129 147 148 128 128 149 131 ICV_3 $T=59670 15910 0 0 $X=59670 $Y=16250
X39 VDD GND 105 129 117 126 132 139 107 131 118 128 134 138 ICV_3 $T=68170 8110 0 0 $X=68170 $Y=8450
X40 GND VDD S<1> S<0> 2 1 ICV_4 $T=9115 3070 1 180 $X=2670 $Y=3600
X41 GND VDD S<3> S<2> 4 3 ICV_4 $T=18615 3070 1 180 $X=12170 $Y=3600
X42 GND VDD S<5> S<4> 6 5 ICV_4 $T=28115 3070 1 180 $X=21670 $Y=3600
X43 GND VDD S<7> S<6> 8 7 ICV_4 $T=37615 3070 1 180 $X=31170 $Y=3600
X44 GND VDD S<9> S<8> 10 9 ICV_4 $T=47115 3070 1 180 $X=40670 $Y=3600
X45 GND VDD S<11> S<10> 12 11 ICV_4 $T=56615 3070 1 180 $X=50170 $Y=3600
X46 GND VDD S<13> S<12> 14 13 ICV_4 $T=66115 3070 1 180 $X=59670 $Y=3600
X47 71 69 GND VDD 74 75 69 78 79 81 ICV_5 $T=2670 8400 0 0 $X=2670 $Y=8450
X48 Cin 71 GND VDD 73 76 71 77 80 82 ICV_5 $T=2670 16200 0 0 $X=2670 $Y=16250
X49 69 69 GND VDD 83 84 86 87 88 72 ICV_5 $T=12170 8400 0 0 $X=12170 $Y=8450
X50 72 72 GND VDD 92 93 95 96 97 99 ICV_5 $T=21670 8400 0 0 $X=21670 $Y=8450
X51 72 72 GND VDD 100 101 103 105 107 108 ICV_5 $T=31170 8400 0 0 $X=31170 $Y=8450
X52 72 72 GND VDD 109 110 112 113 114 116 ICV_5 $T=40670 8400 0 0 $X=40670 $Y=8450
X53 72 72 GND VDD 117 118 120 122 124 70 ICV_5 $T=50170 8400 0 0 $X=50170 $Y=8450
.ENDS
***************************************
